* NGSPICE file created from bist_top.ext - technology: sky130A

* Black-box entry subcircuit for sky130_fd_sc_hd__tapvpwrvgnd_1 abstract view
.subckt sky130_fd_sc_hd__tapvpwrvgnd_1 VGND VPWR
.ends

* Black-box entry subcircuit for sky130_fd_sc_hd__fill_2 abstract view
.subckt sky130_fd_sc_hd__fill_2 VGND VNB VPB VPWR
.ends

* Black-box entry subcircuit for sky130_fd_sc_hd__decap_8 abstract view
.subckt sky130_fd_sc_hd__decap_8 VGND VNB VPB VPWR
.ends

* Black-box entry subcircuit for sky130_fd_sc_hd__fill_1 abstract view
.subckt sky130_fd_sc_hd__fill_1 VGND VNB VPB VPWR
.ends

* Black-box entry subcircuit for sky130_fd_sc_hd__decap_3 abstract view
.subckt sky130_fd_sc_hd__decap_3 VGND VNB VPB VPWR
.ends

* Black-box entry subcircuit for sky130_ef_sc_hd__decap_12 abstract view
.subckt sky130_ef_sc_hd__decap_12 VPWR VGND VPB VNB
.ends

* Black-box entry subcircuit for sky130_fd_sc_hd__dfxtp_1 abstract view
.subckt sky130_fd_sc_hd__dfxtp_1 CLK D VGND VNB VPB VPWR Q
.ends

* Black-box entry subcircuit for sky130_fd_sc_hd__mux2_1 abstract view
.subckt sky130_fd_sc_hd__mux2_1 A0 A1 S VGND VNB VPB VPWR X
.ends

* Black-box entry subcircuit for sky130_fd_sc_hd__a22o_1 abstract view
.subckt sky130_fd_sc_hd__a22o_1 A1 A2 B1 B2 VGND VNB VPB VPWR X
.ends

* Black-box entry subcircuit for sky130_fd_sc_hd__dfrtp_1 abstract view
.subckt sky130_fd_sc_hd__dfrtp_1 CLK D RESET_B VGND VNB VPB VPWR Q
.ends

* Black-box entry subcircuit for sky130_fd_sc_hd__clkbuf_8 abstract view
.subckt sky130_fd_sc_hd__clkbuf_8 A VGND VNB VPB VPWR X
.ends

* Black-box entry subcircuit for sky130_fd_sc_hd__clkbuf_1 abstract view
.subckt sky130_fd_sc_hd__clkbuf_1 A VGND VNB VPB VPWR X
.ends

* Black-box entry subcircuit for sky130_fd_sc_hd__a21bo_1 abstract view
.subckt sky130_fd_sc_hd__a21bo_1 A1 A2 B1_N VGND VNB VPB VPWR X
.ends

* Black-box entry subcircuit for sky130_fd_sc_hd__decap_6 abstract view
.subckt sky130_fd_sc_hd__decap_6 VGND VNB VPB VPWR
.ends

* Black-box entry subcircuit for sky130_fd_sc_hd__clkbuf_2 abstract view
.subckt sky130_fd_sc_hd__clkbuf_2 A VGND VNB VPB VPWR X
.ends

* Black-box entry subcircuit for sky130_fd_sc_hd__decap_4 abstract view
.subckt sky130_fd_sc_hd__decap_4 VGND VNB VPB VPWR
.ends

* Black-box entry subcircuit for sky130_fd_sc_hd__and3_1 abstract view
.subckt sky130_fd_sc_hd__and3_1 A B C VGND VNB VPB VPWR X
.ends

* Black-box entry subcircuit for sky130_fd_sc_hd__or2_1 abstract view
.subckt sky130_fd_sc_hd__or2_1 A B VGND VNB VPB VPWR X
.ends

* Black-box entry subcircuit for sky130_fd_sc_hd__clkbuf_4 abstract view
.subckt sky130_fd_sc_hd__clkbuf_4 A VGND VNB VPB VPWR X
.ends

* Black-box entry subcircuit for sky130_fd_sc_hd__a311o_1 abstract view
.subckt sky130_fd_sc_hd__a311o_1 A1 A2 A3 B1 C1 VGND VNB VPB VPWR X
.ends

* Black-box entry subcircuit for sky130_fd_sc_hd__dlygate4sd3_1 abstract view
.subckt sky130_fd_sc_hd__dlygate4sd3_1 A VGND VNB VPB VPWR X
.ends

* Black-box entry subcircuit for sky130_fd_sc_hd__nor2b_2 abstract view
.subckt sky130_fd_sc_hd__nor2b_2 A B_N VGND VNB VPB VPWR Y
.ends

* Black-box entry subcircuit for sky130_fd_sc_hd__a2bb2o_1 abstract view
.subckt sky130_fd_sc_hd__a2bb2o_1 A1_N A2_N B1 B2 VGND VNB VPB VPWR X
.ends

* Black-box entry subcircuit for sky130_fd_sc_hd__buf_2 abstract view
.subckt sky130_fd_sc_hd__buf_2 A VGND VNB VPB VPWR X
.ends

* Black-box entry subcircuit for sky130_fd_sc_hd__nand2_1 abstract view
.subckt sky130_fd_sc_hd__nand2_1 A B VGND VNB VPB VPWR Y
.ends

* Black-box entry subcircuit for sky130_fd_sc_hd__and4bb_4 abstract view
.subckt sky130_fd_sc_hd__and4bb_4 A_N B_N C D VGND VNB VPB VPWR X
.ends

* Black-box entry subcircuit for sky130_fd_sc_hd__inv_2 abstract view
.subckt sky130_fd_sc_hd__inv_2 A VGND VNB VPB VPWR Y
.ends

* Black-box entry subcircuit for sky130_fd_sc_hd__and2b_1 abstract view
.subckt sky130_fd_sc_hd__and2b_1 A_N B VGND VNB VPB VPWR X
.ends

* Black-box entry subcircuit for sky130_fd_sc_hd__nor2_1 abstract view
.subckt sky130_fd_sc_hd__nor2_1 A B VGND VNB VPB VPWR Y
.ends

* Black-box entry subcircuit for sky130_fd_sc_hd__or3b_1 abstract view
.subckt sky130_fd_sc_hd__or3b_1 A B C_N VGND VNB VPB VPWR X
.ends

* Black-box entry subcircuit for sky130_fd_sc_hd__a221o_1 abstract view
.subckt sky130_fd_sc_hd__a221o_1 A1 A2 B1 B2 C1 VGND VNB VPB VPWR X
.ends

* Black-box entry subcircuit for sky130_fd_sc_hd__a211o_1 abstract view
.subckt sky130_fd_sc_hd__a211o_1 A1 A2 B1 C1 VGND VNB VPB VPWR X
.ends

* Black-box entry subcircuit for sky130_fd_sc_hd__or3_4 abstract view
.subckt sky130_fd_sc_hd__or3_4 A B C VGND VNB VPB VPWR X
.ends

* Black-box entry subcircuit for sky130_fd_sc_hd__nor4_1 abstract view
.subckt sky130_fd_sc_hd__nor4_1 A B C D VGND VNB VPB VPWR Y
.ends

* Black-box entry subcircuit for sky130_fd_sc_hd__or3b_4 abstract view
.subckt sky130_fd_sc_hd__or3b_4 A B C_N VGND VNB VPB VPWR X
.ends

* Black-box entry subcircuit for sky130_fd_sc_hd__or4b_2 abstract view
.subckt sky130_fd_sc_hd__or4b_2 A B C D_N VGND VNB VPB VPWR X
.ends

* Black-box entry subcircuit for sky130_fd_sc_hd__and2_1 abstract view
.subckt sky130_fd_sc_hd__and2_1 A B VGND VNB VPB VPWR X
.ends

* Black-box entry subcircuit for sky130_fd_sc_hd__nand3b_4 abstract view
.subckt sky130_fd_sc_hd__nand3b_4 A_N B C VGND VNB VPB VPWR Y
.ends

* Black-box entry subcircuit for sky130_fd_sc_hd__a32o_1 abstract view
.subckt sky130_fd_sc_hd__a32o_1 A1 A2 A3 B1 B2 VGND VNB VPB VPWR X
.ends

* Black-box entry subcircuit for sky130_fd_sc_hd__or3_1 abstract view
.subckt sky130_fd_sc_hd__or3_1 A B C VGND VNB VPB VPWR X
.ends

* Black-box entry subcircuit for sky130_fd_sc_hd__a31o_1 abstract view
.subckt sky130_fd_sc_hd__a31o_1 A1 A2 A3 B1 VGND VNB VPB VPWR X
.ends

* Black-box entry subcircuit for sky130_fd_sc_hd__or2_2 abstract view
.subckt sky130_fd_sc_hd__or2_2 A B VGND VNB VPB VPWR X
.ends

* Black-box entry subcircuit for sky130_fd_sc_hd__and4_1 abstract view
.subckt sky130_fd_sc_hd__and4_1 A B C D VGND VNB VPB VPWR X
.ends

* Black-box entry subcircuit for sky130_fd_sc_hd__clkbuf_16 abstract view
.subckt sky130_fd_sc_hd__clkbuf_16 A VGND VNB VPB VPWR X
.ends

* Black-box entry subcircuit for sky130_fd_sc_hd__o21ai_1 abstract view
.subckt sky130_fd_sc_hd__o21ai_1 A1 A2 B1 VGND VNB VPB VPWR Y
.ends

* Black-box entry subcircuit for sky130_fd_sc_hd__or3_2 abstract view
.subckt sky130_fd_sc_hd__or3_2 A B C VGND VNB VPB VPWR X
.ends

* Black-box entry subcircuit for sky130_fd_sc_hd__or2b_1 abstract view
.subckt sky130_fd_sc_hd__or2b_1 A B_N VGND VNB VPB VPWR X
.ends

* Black-box entry subcircuit for sky130_fd_sc_hd__a21o_1 abstract view
.subckt sky130_fd_sc_hd__a21o_1 A1 A2 B1 VGND VNB VPB VPWR X
.ends

* Black-box entry subcircuit for sky130_fd_sc_hd__or4b_4 abstract view
.subckt sky130_fd_sc_hd__or4b_4 A B C D_N VGND VNB VPB VPWR X
.ends

* Black-box entry subcircuit for sky130_fd_sc_hd__o31a_1 abstract view
.subckt sky130_fd_sc_hd__o31a_1 A1 A2 A3 B1 VGND VNB VPB VPWR X
.ends

* Black-box entry subcircuit for sky130_fd_sc_hd__a211oi_1 abstract view
.subckt sky130_fd_sc_hd__a211oi_1 A1 A2 B1 C1 VGND VNB VPB VPWR Y
.ends

* Black-box entry subcircuit for sky130_fd_sc_hd__or4_2 abstract view
.subckt sky130_fd_sc_hd__or4_2 A B C D VGND VNB VPB VPWR X
.ends

* Black-box entry subcircuit for sky130_fd_sc_hd__o21a_1 abstract view
.subckt sky130_fd_sc_hd__o21a_1 A1 A2 B1 VGND VNB VPB VPWR X
.ends

* Black-box entry subcircuit for sky130_fd_sc_hd__o21bai_1 abstract view
.subckt sky130_fd_sc_hd__o21bai_1 A1 A2 B1_N VGND VNB VPB VPWR Y
.ends

* Black-box entry subcircuit for sky130_fd_sc_hd__buf_1 abstract view
.subckt sky130_fd_sc_hd__buf_1 A VGND VNB VPB VPWR X
.ends

* Black-box entry subcircuit for sky130_fd_sc_hd__a2111o_1 abstract view
.subckt sky130_fd_sc_hd__a2111o_1 A1 A2 B1 C1 D1 VGND VNB VPB VPWR X
.ends

* Black-box entry subcircuit for sky130_fd_sc_hd__or4_1 abstract view
.subckt sky130_fd_sc_hd__or4_1 A B C D VGND VNB VPB VPWR X
.ends

* Black-box entry subcircuit for sky130_fd_sc_hd__dfrtp_4 abstract view
.subckt sky130_fd_sc_hd__dfrtp_4 CLK D RESET_B VGND VNB VPB VPWR Q
.ends

* Black-box entry subcircuit for sky130_fd_sc_hd__and4bb_1 abstract view
.subckt sky130_fd_sc_hd__and4bb_1 A_N B_N C D VGND VNB VPB VPWR X
.ends

* Black-box entry subcircuit for sky130_fd_sc_hd__buf_4 abstract view
.subckt sky130_fd_sc_hd__buf_4 A VGND VNB VPB VPWR X
.ends

* Black-box entry subcircuit for sky130_fd_sc_hd__nor4b_2 abstract view
.subckt sky130_fd_sc_hd__nor4b_2 A B C D_N VGND VNB VPB VPWR Y
.ends

* Black-box entry subcircuit for sky130_fd_sc_hd__and4b_4 abstract view
.subckt sky130_fd_sc_hd__and4b_4 A_N B C D VGND VNB VPB VPWR X
.ends

* Black-box entry subcircuit for sky130_fd_sc_hd__dfrtp_2 abstract view
.subckt sky130_fd_sc_hd__dfrtp_2 CLK D RESET_B VGND VNB VPB VPWR Q
.ends

* Black-box entry subcircuit for sky130_fd_sc_hd__and3b_1 abstract view
.subckt sky130_fd_sc_hd__and3b_1 A_N B C VGND VNB VPB VPWR X
.ends

* Black-box entry subcircuit for sky130_fd_sc_hd__xnor2_1 abstract view
.subckt sky130_fd_sc_hd__xnor2_1 A B VGND VNB VPB VPWR Y
.ends

* Black-box entry subcircuit for sky130_fd_sc_hd__dfstp_1 abstract view
.subckt sky130_fd_sc_hd__dfstp_1 CLK D SET_B VGND VNB VPB VPWR Q
.ends

* Black-box entry subcircuit for sky130_fd_sc_hd__and4_4 abstract view
.subckt sky130_fd_sc_hd__and4_4 A B C D VGND VNB VPB VPWR X
.ends

* Black-box entry subcircuit for sky130_fd_sc_hd__nand3_4 abstract view
.subckt sky130_fd_sc_hd__nand3_4 A B C VGND VNB VPB VPWR Y
.ends

* Black-box entry subcircuit for sky130_fd_sc_hd__nand2_2 abstract view
.subckt sky130_fd_sc_hd__nand2_2 A B VGND VNB VPB VPWR Y
.ends

* Black-box entry subcircuit for sky130_fd_sc_hd__o221a_1 abstract view
.subckt sky130_fd_sc_hd__o221a_1 A1 A2 B1 B2 C1 VGND VNB VPB VPWR X
.ends

* Black-box entry subcircuit for sky130_fd_sc_hd__o21ba_2 abstract view
.subckt sky130_fd_sc_hd__o21ba_2 A1 A2 B1_N VGND VNB VPB VPWR X
.ends

* Black-box entry subcircuit for sky130_fd_sc_hd__or3b_2 abstract view
.subckt sky130_fd_sc_hd__or3b_2 A B C_N VGND VNB VPB VPWR X
.ends

* Black-box entry subcircuit for sky130_fd_sc_hd__xor2_2 abstract view
.subckt sky130_fd_sc_hd__xor2_2 A B VGND VNB VPB VPWR X
.ends

* Black-box entry subcircuit for sky130_fd_sc_hd__and2_2 abstract view
.subckt sky130_fd_sc_hd__and2_2 A B VGND VNB VPB VPWR X
.ends

* Black-box entry subcircuit for sky130_fd_sc_hd__a21oi_1 abstract view
.subckt sky130_fd_sc_hd__a21oi_1 A1 A2 B1 VGND VNB VPB VPWR Y
.ends

.subckt bist_top VGND VPWR clk done pass_fail rst_n start
XTAP_177 VGND VPWR sky130_fd_sc_hd__tapvpwrvgnd_1
XTAP_188 VGND VPWR sky130_fd_sc_hd__tapvpwrvgnd_1
XTAP_199 VGND VPWR sky130_fd_sc_hd__tapvpwrvgnd_1
XFILLER_0_17_255 VGND VGND VPWR VPWR sky130_fd_sc_hd__fill_2
XFILLER_0_32_236 VGND VGND VPWR VPWR sky130_fd_sc_hd__decap_8
XFILLER_0_32_203 VGND VGND VPWR VPWR sky130_fd_sc_hd__fill_1
XFILLER_0_4_193 VGND VGND VPWR VPWR sky130_fd_sc_hd__decap_3
XFILLER_0_48_15 VPWR VGND VPWR VGND sky130_ef_sc_hd__decap_12
X_1270_ clknet_4_4_0_clk _0104_ VGND VGND VPWR VPWR u_sram.mem\[18\]\[0\] sky130_fd_sc_hd__dfxtp_1
XFILLER_0_3_39 VPWR VGND VPWR VGND sky130_ef_sc_hd__decap_12
XFILLER_0_13_40 VGND VGND VPWR VPWR sky130_fd_sc_hd__decap_8
X_0985_ net60 _0366_ _0396_ VGND VGND VPWR VPWR _0398_ sky130_fd_sc_hd__mux2_1
XFILLER_0_14_225 VGND VGND VPWR VPWR sky130_fd_sc_hd__fill_1
XFILLER_0_1_163 VGND VGND VPWR VPWR sky130_fd_sc_hd__fill_2
XFILLER_0_50_27 VGND VGND VPWR VPWR sky130_fd_sc_hd__fill_1
X_0770_ u_sram.mem\[54\]\[1\] _0175_ _0189_ u_sram.mem\[63\]\[1\] VGND VGND VPWR VPWR
+ _0219_ sky130_fd_sc_hd__a22o_1
X_1253_ clknet_4_5_0_clk _0087_ VGND VGND VPWR VPWR u_sram.mem\[26\]\[1\] sky130_fd_sc_hd__dfxtp_1
X_1322_ clknet_4_10_0_clk net25 net12 VGND VGND VPWR VPWR u_fsm.fail_latch sky130_fd_sc_hd__dfrtp_1
X_1184_ clknet_4_3_0_clk _0018_ VGND VGND VPWR VPWR u_sram.mem\[61\]\[0\] sky130_fd_sc_hd__dfxtp_1
Xclkbuf_4_12_0_clk clknet_0_clk VGND VGND VPWR VPWR clknet_4_12_0_clk sky130_fd_sc_hd__clkbuf_8
XFILLER_0_6_277 VPWR VGND VPWR VGND sky130_ef_sc_hd__decap_12
X_0968_ _0386_ VGND VGND VPWR VPWR _0032_ sky130_fd_sc_hd__clkbuf_1
X_0899_ _0324_ _0329_ _0326_ VGND VGND VPWR VPWR _0338_ sky130_fd_sc_hd__a21bo_1
XFILLER_0_37_103 VGND VGND VPWR VPWR sky130_fd_sc_hd__fill_2
XFILLER_0_45_180 VGND VGND VPWR VPWR sky130_fd_sc_hd__fill_2
XFILLER_0_37_169 VGND VGND VPWR VPWR sky130_fd_sc_hd__decap_6
XFILLER_0_45_27 VPWR VGND VPWR VGND sky130_ef_sc_hd__decap_12
Xmax_cap5 _0186_ VGND VGND VPWR VPWR net5 sky130_fd_sc_hd__clkbuf_2
XFILLER_0_0_29 VPWR VGND VPWR VGND sky130_ef_sc_hd__decap_12
XFILLER_0_9_27 VGND VGND VPWR VPWR sky130_fd_sc_hd__decap_3
XFILLER_0_28_136 VGND VGND VPWR VPWR sky130_fd_sc_hd__decap_4
X_0822_ u_sram.mem\[17\]\[0\] net11 _0184_ VGND VGND VPWR VPWR _0270_ sky130_fd_sc_hd__and3_1
X_0753_ _0185_ _0198_ _0201_ _0169_ VGND VGND VPWR VPWR _0202_ sky130_fd_sc_hd__a22o_1
XFILLER_0_3_225 VPWR VGND VPWR VGND sky130_ef_sc_hd__decap_12
XFILLER_0_10_85 VGND VGND VPWR VPWR sky130_fd_sc_hd__decap_4
X_0684_ _0575_ VGND VGND VPWR VPWR _0146_ sky130_fd_sc_hd__clkbuf_1
X_1236_ clknet_4_7_0_clk _0070_ VGND VGND VPWR VPWR u_sram.mem\[35\]\[0\] sky130_fd_sc_hd__dfxtp_1
X_1305_ clknet_4_10_0_clk _0139_ VGND VGND VPWR VPWR u_sram.mem\[0\]\[1\] sky130_fd_sc_hd__dfxtp_1
X_1098_ net87 _0437_ _0469_ VGND VGND VPWR VPWR _0471_ sky130_fd_sc_hd__mux2_1
X_1167_ _0403_ _0468_ VGND VGND VPWR VPWR _0513_ sky130_fd_sc_hd__or2_1
XFILLER_0_51_81 VGND VGND VPWR VPWR sky130_fd_sc_hd__decap_3
XFILLER_0_34_117 VPWR VGND VPWR VGND sky130_ef_sc_hd__decap_12
XFILLER_0_30_301 VGND VGND VPWR VPWR sky130_fd_sc_hd__decap_4
XFILLER_0_27_191 VGND VGND VPWR VPWR sky130_fd_sc_hd__fill_2
XFILLER_0_33_172 VGND VGND VPWR VPWR sky130_fd_sc_hd__fill_1
X_1021_ _0350_ VGND VGND VPWR VPWR _0422_ sky130_fd_sc_hd__clkbuf_4
X_0805_ u_sram.mem\[47\]\[0\] _0168_ _0189_ _0251_ _0252_ VGND VGND VPWR VPWR _0253_
+ sky130_fd_sc_hd__a311o_1
XFILLER_0_21_51 VGND VGND VPWR VPWR sky130_fd_sc_hd__fill_2
X_0667_ _0407_ _0520_ VGND VGND VPWR VPWR _0566_ sky130_fd_sc_hd__or2_1
X_0598_ _0503_ net134 _0524_ VGND VGND VPWR VPWR _0525_ sky130_fd_sc_hd__mux2_1
X_0736_ _0184_ VGND VGND VPWR VPWR _0185_ sky130_fd_sc_hd__clkbuf_4
XFILLER_0_34_3 VPWR VGND VPWR VGND sky130_ef_sc_hd__decap_12
X_1219_ clknet_4_9_0_clk _0053_ VGND VGND VPWR VPWR u_sram.mem\[43\]\[1\] sky130_fd_sc_hd__dfxtp_1
Xhold74 u_sram.mem\[38\]\[1\] VGND VGND VPWR VPWR net90 sky130_fd_sc_hd__dlygate4sd3_1
Xhold41 u_sram.mem\[40\]\[0\] VGND VGND VPWR VPWR net57 sky130_fd_sc_hd__dlygate4sd3_1
Xhold63 u_sram.mem\[63\]\[0\] VGND VGND VPWR VPWR net79 sky130_fd_sc_hd__dlygate4sd3_1
Xhold52 u_sram.mem\[7\]\[0\] VGND VGND VPWR VPWR net68 sky130_fd_sc_hd__dlygate4sd3_1
XFILLER_0_26_29 VPWR VGND VPWR VGND sky130_ef_sc_hd__decap_12
Xhold30 u_sram.mem\[21\]\[1\] VGND VGND VPWR VPWR net46 sky130_fd_sc_hd__dlygate4sd3_1
XFILLER_0_30_197 VGND VGND VPWR VPWR sky130_fd_sc_hd__decap_3
Xhold96 u_sram.mem\[38\]\[0\] VGND VGND VPWR VPWR net112 sky130_fd_sc_hd__dlygate4sd3_1
Xhold85 u_sram.mem\[32\]\[1\] VGND VGND VPWR VPWR net101 sky130_fd_sc_hd__dlygate4sd3_1
XFILLER_0_38_253 VPWR VGND VPWR VGND sky130_ef_sc_hd__decap_12
XFILLER_0_13_109 VGND VGND VPWR VPWR sky130_fd_sc_hd__decap_3
XTAP_348 VGND VPWR sky130_fd_sc_hd__tapvpwrvgnd_1
XTAP_337 VGND VPWR sky130_fd_sc_hd__tapvpwrvgnd_1
XTAP_326 VGND VPWR sky130_fd_sc_hd__tapvpwrvgnd_1
XTAP_315 VGND VPWR sky130_fd_sc_hd__tapvpwrvgnd_1
XTAP_304 VGND VPWR sky130_fd_sc_hd__tapvpwrvgnd_1
XFILLER_0_21_197 VGND VGND VPWR VPWR sky130_fd_sc_hd__fill_1
XTAP_359 VGND VPWR sky130_fd_sc_hd__tapvpwrvgnd_1
XFILLER_0_32_83 VGND VGND VPWR VPWR sky130_fd_sc_hd__fill_1
X_1004_ _0410_ VGND VGND VPWR VPWR _0044_ sky130_fd_sc_hd__clkbuf_1
XFILLER_0_44_289 VPWR VGND VPWR VGND sky130_ef_sc_hd__decap_12
XFILLER_0_44_245 VGND VGND VPWR VPWR sky130_fd_sc_hd__decap_6
XFILLER_0_12_197 VGND VGND VPWR VPWR sky130_fd_sc_hd__decap_8
X_0719_ u_sram.addr_r\[4\] u_sram.addr_r\[5\] VGND VGND VPWR VPWR _0168_ sky130_fd_sc_hd__nor2b_2
XFILLER_0_41_248 VPWR VGND VPWR VGND sky130_ef_sc_hd__decap_12
XFILLER_0_5_139 VGND VGND VPWR VPWR sky130_fd_sc_hd__fill_1
XTAP_145 VGND VPWR sky130_fd_sc_hd__tapvpwrvgnd_1
XTAP_134 VGND VPWR sky130_fd_sc_hd__tapvpwrvgnd_1
XTAP_123 VGND VPWR sky130_fd_sc_hd__tapvpwrvgnd_1
XTAP_112 VGND VPWR sky130_fd_sc_hd__tapvpwrvgnd_1
XTAP_156 VGND VPWR sky130_fd_sc_hd__tapvpwrvgnd_1
XTAP_167 VGND VPWR sky130_fd_sc_hd__tapvpwrvgnd_1
XTAP_178 VGND VPWR sky130_fd_sc_hd__tapvpwrvgnd_1
XTAP_189 VGND VPWR sky130_fd_sc_hd__tapvpwrvgnd_1
XFILLER_0_27_72 VPWR VGND VPWR VGND sky130_ef_sc_hd__decap_12
XFILLER_0_17_245 VGND VGND VPWR VPWR sky130_fd_sc_hd__fill_1
XFILLER_0_4_150 VGND VGND VPWR VPWR sky130_fd_sc_hd__fill_1
XFILLER_0_23_19 VGND VGND VPWR VPWR sky130_fd_sc_hd__fill_1
XFILLER_0_2_109 VPWR VGND VPWR VGND sky130_ef_sc_hd__decap_12
XFILLER_0_48_27 VGND VGND VPWR VPWR sky130_fd_sc_hd__fill_1
XFILLER_0_31_281 VPWR VGND VPWR VGND sky130_ef_sc_hd__decap_12
X_0984_ _0397_ VGND VGND VPWR VPWR _0037_ sky130_fd_sc_hd__clkbuf_1
XFILLER_0_38_93 VGND VGND VPWR VPWR sky130_fd_sc_hd__fill_2
XFILLER_0_9_220 VGND VGND VPWR VPWR sky130_fd_sc_hd__decap_4
XFILLER_0_9_231 VGND VGND VPWR VPWR sky130_fd_sc_hd__fill_2
XFILLER_0_13_270 VGND VGND VPWR VPWR sky130_fd_sc_hd__decap_8
XFILLER_0_13_292 VGND VGND VPWR VPWR sky130_fd_sc_hd__fill_2
XFILLER_0_34_29 VPWR VGND VPWR VGND sky130_ef_sc_hd__decap_12
X_1252_ clknet_4_5_0_clk _0086_ VGND VGND VPWR VPWR u_sram.mem\[27\]\[0\] sky130_fd_sc_hd__dfxtp_1
X_1321_ clknet_4_10_0_clk u_comparator.enable net12 VGND VGND VPWR VPWR u_comparator.compare_done
+ sky130_fd_sc_hd__dfrtp_1
X_1183_ clknet_4_9_0_clk _0017_ VGND VGND VPWR VPWR u_sram.mem\[61\]\[1\] sky130_fd_sc_hd__dfxtp_1
XFILLER_0_6_289 VPWR VGND VPWR VGND sky130_ef_sc_hd__decap_12
X_0967_ net48 _0366_ _0384_ VGND VGND VPWR VPWR _0386_ sky130_fd_sc_hd__mux2_1
XFILLER_0_49_81 VGND VGND VPWR VPWR sky130_fd_sc_hd__decap_8
X_0898_ _0330_ _0337_ _0331_ _0309_ VGND VGND VPWR VPWR _0011_ sky130_fd_sc_hd__a2bb2o_1
XFILLER_0_4_83 VGND VGND VPWR VPWR sky130_fd_sc_hd__fill_1
XFILLER_0_37_137 VGND VGND VPWR VPWR sky130_fd_sc_hd__decap_4
XFILLER_0_45_39 VGND VGND VPWR VPWR sky130_fd_sc_hd__decap_8
Xmax_cap6 net7 VGND VGND VPWR VPWR net6 sky130_fd_sc_hd__clkbuf_2
X_0752_ u_sram.mem\[42\]\[1\] _0199_ _0200_ u_sram.mem\[44\]\[1\] VGND VGND VPWR VPWR
+ _0201_ sky130_fd_sc_hd__a22o_1
X_0821_ u_sram.mem\[25\]\[0\] _0204_ _0183_ VGND VGND VPWR VPWR _0269_ sky130_fd_sc_hd__and3_1
XFILLER_0_51_195 VGND VGND VPWR VPWR sky130_fd_sc_hd__fill_1
XFILLER_0_3_237 VPWR VGND VPWR VGND sky130_ef_sc_hd__decap_12
X_0683_ net161 _0574_ _0003_ VGND VGND VPWR VPWR _0575_ sky130_fd_sc_hd__mux2_1
X_1235_ clknet_4_7_0_clk _0069_ VGND VGND VPWR VPWR u_sram.mem\[35\]\[1\] sky130_fd_sc_hd__dfxtp_1
X_1304_ clknet_4_9_0_clk _0138_ VGND VGND VPWR VPWR u_sram.mem\[1\]\[0\] sky130_fd_sc_hd__dfxtp_1
X_1166_ _0512_ VGND VGND VPWR VPWR _0104_ sky130_fd_sc_hd__clkbuf_1
X_1097_ _0470_ VGND VGND VPWR VPWR _0077_ sky130_fd_sc_hd__clkbuf_1
XFILLER_0_35_72 VGND VGND VPWR VPWR sky130_fd_sc_hd__fill_1
XFILLER_0_42_195 VGND VGND VPWR VPWR sky130_fd_sc_hd__fill_1
XFILLER_0_34_129 VGND VGND VPWR VPWR sky130_fd_sc_hd__decap_8
XFILLER_0_33_184 VGND VGND VPWR VPWR sky130_fd_sc_hd__decap_4
Xclkbuf_4_11_0_clk clknet_0_clk VGND VGND VPWR VPWR clknet_4_11_0_clk sky130_fd_sc_hd__clkbuf_8
X_1020_ _0421_ VGND VGND VPWR VPWR _0049_ sky130_fd_sc_hd__clkbuf_1
X_0735_ _0183_ VGND VGND VPWR VPWR _0184_ sky130_fd_sc_hd__buf_2
X_0804_ u_sram.mem\[22\]\[0\] _0175_ _0184_ VGND VGND VPWR VPWR _0252_ sky130_fd_sc_hd__and3_1
X_0597_ _0347_ _0519_ VGND VGND VPWR VPWR _0524_ sky130_fd_sc_hd__or2_1
X_0666_ _0565_ VGND VGND VPWR VPWR _0138_ sky130_fd_sc_hd__clkbuf_1
X_1218_ clknet_4_7_0_clk _0052_ VGND VGND VPWR VPWR u_sram.mem\[44\]\[0\] sky130_fd_sc_hd__dfxtp_1
XFILLER_0_1_51 VGND VGND VPWR VPWR sky130_fd_sc_hd__decap_4
XFILLER_0_27_3 VPWR VGND VPWR VGND sky130_ef_sc_hd__decap_12
X_1149_ net50 _0350_ _0500_ VGND VGND VPWR VPWR _0502_ sky130_fd_sc_hd__mux2_1
Xhold42 u_sram.mem\[26\]\[1\] VGND VGND VPWR VPWR net58 sky130_fd_sc_hd__dlygate4sd3_1
Xhold53 u_sram.mem\[59\]\[1\] VGND VGND VPWR VPWR net69 sky130_fd_sc_hd__dlygate4sd3_1
Xhold75 u_sram.mem\[60\]\[1\] VGND VGND VPWR VPWR net91 sky130_fd_sc_hd__dlygate4sd3_1
Xhold86 u_sram.mem\[52\]\[0\] VGND VGND VPWR VPWR net102 sky130_fd_sc_hd__dlygate4sd3_1
Xhold64 u_sram.mem\[57\]\[0\] VGND VGND VPWR VPWR net80 sky130_fd_sc_hd__dlygate4sd3_1
Xhold20 u_sram.mem\[41\]\[1\] VGND VGND VPWR VPWR net36 sky130_fd_sc_hd__dlygate4sd3_1
Xhold97 u_sram.mem\[10\]\[1\] VGND VGND VPWR VPWR net113 sky130_fd_sc_hd__dlygate4sd3_1
Xhold31 u_sram.mem\[16\]\[0\] VGND VGND VPWR VPWR net47 sky130_fd_sc_hd__dlygate4sd3_1
XFILLER_0_38_265 VPWR VGND VPWR VGND sky130_ef_sc_hd__decap_12
XFILLER_0_38_221 VGND VGND VPWR VPWR sky130_fd_sc_hd__fill_2
XTAP_349 VGND VPWR sky130_fd_sc_hd__tapvpwrvgnd_1
XTAP_338 VGND VPWR sky130_fd_sc_hd__tapvpwrvgnd_1
XTAP_327 VGND VPWR sky130_fd_sc_hd__tapvpwrvgnd_1
XTAP_316 VGND VPWR sky130_fd_sc_hd__tapvpwrvgnd_1
XTAP_305 VGND VPWR sky130_fd_sc_hd__tapvpwrvgnd_1
XFILLER_0_6_29 VPWR VGND VPWR VGND sky130_ef_sc_hd__decap_12
X_1003_ _0351_ net151 _0408_ VGND VGND VPWR VPWR _0410_ sky130_fd_sc_hd__mux2_1
XFILLER_0_16_85 VGND VGND VPWR VPWR sky130_fd_sc_hd__decap_6
XFILLER_0_29_221 VGND VGND VPWR VPWR sky130_fd_sc_hd__decap_3
X_0718_ net10 _0166_ VGND VGND VPWR VPWR _0167_ sky130_fd_sc_hd__nand2_1
X_0649_ _0555_ VGND VGND VPWR VPWR _0131_ sky130_fd_sc_hd__clkbuf_1
XFILLER_0_35_279 VGND VGND VPWR VPWR sky130_fd_sc_hd__fill_1
XFILLER_0_5_129 VGND VGND VPWR VPWR sky130_fd_sc_hd__fill_1
XTAP_146 VGND VPWR sky130_fd_sc_hd__tapvpwrvgnd_1
XTAP_135 VGND VPWR sky130_fd_sc_hd__tapvpwrvgnd_1
XTAP_124 VGND VPWR sky130_fd_sc_hd__tapvpwrvgnd_1
XTAP_113 VGND VPWR sky130_fd_sc_hd__tapvpwrvgnd_1
XTAP_157 VGND VPWR sky130_fd_sc_hd__tapvpwrvgnd_1
XTAP_168 VGND VPWR sky130_fd_sc_hd__tapvpwrvgnd_1
XTAP_179 VGND VPWR sky130_fd_sc_hd__tapvpwrvgnd_1
XFILLER_0_49_305 VGND VGND VPWR VPWR sky130_fd_sc_hd__fill_1
XFILLER_0_27_84 VGND VGND VPWR VPWR sky130_fd_sc_hd__decap_8
XFILLER_0_31_293 VPWR VGND VPWR VGND sky130_ef_sc_hd__decap_12
X_0983_ net55 _0361_ _0396_ VGND VGND VPWR VPWR _0397_ sky130_fd_sc_hd__mux2_1
XFILLER_0_50_29 VPWR VGND VPWR VGND sky130_ef_sc_hd__decap_12
X_1320_ clknet_4_14_0_clk _0144_ net16 VGND VGND VPWR VPWR u_addr_gen.addr_valid sky130_fd_sc_hd__dfrtp_1
X_1251_ clknet_4_5_0_clk _0085_ VGND VGND VPWR VPWR u_sram.mem\[27\]\[1\] sky130_fd_sc_hd__dfxtp_1
X_1182_ clknet_4_10_0_clk _0016_ VGND VGND VPWR VPWR u_sram.mem\[62\]\[0\] sky130_fd_sc_hd__dfxtp_1
XFILLER_0_40_62 VGND VGND VPWR VPWR sky130_fd_sc_hd__fill_1
X_0897_ _0336_ VGND VGND VPWR VPWR _0337_ sky130_fd_sc_hd__buf_2
X_0966_ _0385_ VGND VGND VPWR VPWR _0031_ sky130_fd_sc_hd__clkbuf_1
XFILLER_0_29_19 VGND VGND VPWR VPWR sky130_fd_sc_hd__fill_1
Xmax_cap7 _0177_ VGND VGND VPWR VPWR net7 sky130_fd_sc_hd__clkbuf_2
XFILLER_0_51_141 VPWR VGND VPWR VGND sky130_ef_sc_hd__decap_12
XFILLER_0_43_108 VGND VGND VPWR VPWR sky130_fd_sc_hd__decap_4
X_0751_ _0172_ _0170_ _0171_ _0163_ VGND VGND VPWR VPWR _0200_ sky130_fd_sc_hd__and4bb_4
XFILLER_0_3_249 VPWR VGND VPWR VGND sky130_ef_sc_hd__decap_12
X_0820_ u_sram.mem\[45\]\[0\] _0168_ _0207_ VGND VGND VPWR VPWR _0268_ sky130_fd_sc_hd__and3_1
XFILLER_0_28_149 VGND VGND VPWR VPWR sky130_fd_sc_hd__decap_6
X_0682_ u_fsm.fail_latch VGND VGND VPWR VPWR _0574_ sky130_fd_sc_hd__inv_2
X_1303_ clknet_4_11_0_clk _0137_ VGND VGND VPWR VPWR u_sram.mem\[1\]\[1\] sky130_fd_sc_hd__dfxtp_1
X_1234_ clknet_4_7_0_clk _0068_ VGND VGND VPWR VPWR u_sram.mem\[36\]\[0\] sky130_fd_sc_hd__dfxtp_1
X_1096_ net77 _0434_ _0469_ VGND VGND VPWR VPWR _0470_ sky130_fd_sc_hd__mux2_1
X_1165_ _0492_ net120 _0510_ VGND VGND VPWR VPWR _0512_ sky130_fd_sc_hd__mux2_1
XFILLER_0_19_138 VGND VGND VPWR VPWR sky130_fd_sc_hd__decap_6
XFILLER_0_42_141 VGND VGND VPWR VPWR sky130_fd_sc_hd__decap_6
X_0949_ _0374_ VGND VGND VPWR VPWR _0025_ sky130_fd_sc_hd__clkbuf_1
X_0665_ _0320_ net53 _0563_ VGND VGND VPWR VPWR _0565_ sky130_fd_sc_hd__mux2_1
XFILLER_0_24_130 VGND VGND VPWR VPWR sky130_fd_sc_hd__fill_1
XFILLER_0_24_141 VPWR VGND VPWR VGND sky130_ef_sc_hd__decap_12
X_0734_ u_sram.addr_r\[5\] u_sram.addr_r\[4\] VGND VGND VPWR VPWR _0183_ sky130_fd_sc_hd__and2b_1
X_0803_ u_sram.mem\[21\]\[0\] _0173_ _0184_ VGND VGND VPWR VPWR _0251_ sky130_fd_sc_hd__and3_1
X_0596_ _0523_ VGND VGND VPWR VPWR _0110_ sky130_fd_sc_hd__clkbuf_1
X_1079_ _0458_ VGND VGND VPWR VPWR _0071_ sky130_fd_sc_hd__clkbuf_1
XFILLER_0_46_83 VGND VGND VPWR VPWR sky130_fd_sc_hd__fill_1
X_1217_ clknet_4_7_0_clk _0051_ VGND VGND VPWR VPWR u_sram.mem\[44\]\[1\] sky130_fd_sc_hd__dfxtp_1
X_1148_ _0501_ VGND VGND VPWR VPWR _0097_ sky130_fd_sc_hd__clkbuf_1
Xhold76 u_sram.mem\[37\]\[1\] VGND VGND VPWR VPWR net92 sky130_fd_sc_hd__dlygate4sd3_1
Xhold43 u_sram.mem\[24\]\[1\] VGND VGND VPWR VPWR net59 sky130_fd_sc_hd__dlygate4sd3_1
Xhold21 u_sram.mem\[30\]\[0\] VGND VGND VPWR VPWR net37 sky130_fd_sc_hd__dlygate4sd3_1
Xhold54 u_sram.mem\[55\]\[1\] VGND VGND VPWR VPWR net70 sky130_fd_sc_hd__dlygate4sd3_1
Xhold65 u_sram.mem\[52\]\[1\] VGND VGND VPWR VPWR net81 sky130_fd_sc_hd__dlygate4sd3_1
Xhold32 u_sram.mem\[54\]\[0\] VGND VGND VPWR VPWR net48 sky130_fd_sc_hd__dlygate4sd3_1
Xhold87 u_sram.mem\[61\]\[0\] VGND VGND VPWR VPWR net103 sky130_fd_sc_hd__dlygate4sd3_1
Xhold10 u_addr_gen.addr\[4\] VGND VGND VPWR VPWR net26 sky130_fd_sc_hd__dlygate4sd3_1
Xhold98 u_sram.mem\[20\]\[0\] VGND VGND VPWR VPWR net114 sky130_fd_sc_hd__dlygate4sd3_1
XFILLER_0_38_277 VPWR VGND VPWR VGND sky130_ef_sc_hd__decap_12
XFILLER_0_21_111 VGND VGND VPWR VPWR sky130_fd_sc_hd__fill_1
XTAP_339 VGND VPWR sky130_fd_sc_hd__tapvpwrvgnd_1
XTAP_328 VGND VPWR sky130_fd_sc_hd__tapvpwrvgnd_1
XTAP_317 VGND VPWR sky130_fd_sc_hd__tapvpwrvgnd_1
XTAP_306 VGND VPWR sky130_fd_sc_hd__tapvpwrvgnd_1
XFILLER_0_21_166 VGND VGND VPWR VPWR sky130_fd_sc_hd__fill_2
X_1002_ _0409_ VGND VGND VPWR VPWR _0043_ sky130_fd_sc_hd__clkbuf_1
XFILLER_0_16_53 VGND VGND VPWR VPWR sky130_fd_sc_hd__decap_8
XFILLER_0_32_85 VGND VGND VPWR VPWR sky130_fd_sc_hd__decap_3
X_0648_ _0308_ net159 _0554_ VGND VGND VPWR VPWR _0555_ sky130_fd_sc_hd__mux2_1
X_0717_ _0165_ VGND VGND VPWR VPWR _0166_ sky130_fd_sc_hd__buf_2
Xclkbuf_4_10_0_clk clknet_0_clk VGND VGND VPWR VPWR clknet_4_10_0_clk sky130_fd_sc_hd__clkbuf_8
XFILLER_0_9_3 VPWR VGND VPWR VGND sky130_ef_sc_hd__decap_12
XFILLER_0_26_203 VGND VGND VPWR VPWR sky130_fd_sc_hd__decap_8
XTAP_114 VGND VPWR sky130_fd_sc_hd__tapvpwrvgnd_1
XTAP_147 VGND VPWR sky130_fd_sc_hd__tapvpwrvgnd_1
XTAP_136 VGND VPWR sky130_fd_sc_hd__tapvpwrvgnd_1
XTAP_125 VGND VPWR sky130_fd_sc_hd__tapvpwrvgnd_1
XTAP_158 VGND VPWR sky130_fd_sc_hd__tapvpwrvgnd_1
XTAP_169 VGND VPWR sky130_fd_sc_hd__tapvpwrvgnd_1
XFILLER_0_43_84 VPWR VGND VPWR VGND sky130_ef_sc_hd__decap_12
XFILLER_0_17_203 VGND VGND VPWR VPWR sky130_fd_sc_hd__fill_1
XFILLER_0_4_163 VGND VGND VPWR VPWR sky130_fd_sc_hd__fill_1
XFILLER_0_17_225 VGND VGND VPWR VPWR sky130_fd_sc_hd__decap_3
XFILLER_0_40_261 VPWR VGND VPWR VGND sky130_ef_sc_hd__decap_12
XFILLER_0_7_95 VPWR VGND VPWR VGND sky130_ef_sc_hd__decap_12
XFILLER_0_48_29 VPWR VGND VPWR VGND sky130_ef_sc_hd__decap_12
X_0982_ _0317_ _0395_ VGND VGND VPWR VPWR _0396_ sky130_fd_sc_hd__nor2_1
XFILLER_0_1_111 VGND VGND VPWR VPWR sky130_fd_sc_hd__fill_1
XFILLER_0_1_199 VGND VGND VPWR VPWR sky130_fd_sc_hd__fill_1
XFILLER_0_22_261 VGND VGND VPWR VPWR sky130_fd_sc_hd__decap_3
Xhold140 u_sram.mem\[46\]\[0\] VGND VGND VPWR VPWR net156 sky130_fd_sc_hd__dlygate4sd3_1
X_1250_ clknet_4_5_0_clk _0084_ VGND VGND VPWR VPWR u_sram.mem\[28\]\[0\] sky130_fd_sc_hd__dfxtp_1
X_1181_ clknet_4_8_0_clk _0015_ VGND VGND VPWR VPWR u_sram.mem\[62\]\[1\] sky130_fd_sc_hd__dfxtp_1
XFILLER_0_42_301 VGND VGND VPWR VPWR sky130_fd_sc_hd__decap_4
X_0896_ _0335_ u_addr_gen.addr\[3\] u_addr_gen.addr\[2\] VGND VGND VPWR VPWR _0336_
+ sky130_fd_sc_hd__or3b_1
X_0965_ net52 _0361_ _0384_ VGND VGND VPWR VPWR _0385_ sky130_fd_sc_hd__mux2_1
XFILLER_0_4_85 VPWR VGND VPWR VGND sky130_ef_sc_hd__decap_12
XFILLER_0_4_41 VPWR VGND VPWR VGND sky130_ef_sc_hd__decap_12
XFILLER_0_10_253 VPWR VGND VPWR VGND sky130_ef_sc_hd__decap_12
Xmax_cap8 net9 VGND VGND VPWR VPWR net8 sky130_fd_sc_hd__clkbuf_2
XFILLER_0_51_197 VPWR VGND VPWR VGND sky130_ef_sc_hd__decap_12
XFILLER_0_51_153 VPWR VGND VPWR VGND sky130_ef_sc_hd__decap_12
X_0750_ _0172_ _0163_ _0171_ _0170_ VGND VGND VPWR VPWR _0199_ sky130_fd_sc_hd__and4bb_4
XFILLER_0_10_77 VGND VGND VPWR VPWR sky130_fd_sc_hd__decap_6
X_0681_ u_comparator.compare_done _0572_ u_fsm.fail_latch _0573_ net24 VGND VGND VPWR
+ VPWR _0145_ sky130_fd_sc_hd__a221o_1
X_1233_ clknet_4_7_0_clk _0067_ VGND VGND VPWR VPWR u_sram.mem\[36\]\[1\] sky130_fd_sc_hd__dfxtp_1
X_1302_ clknet_4_1_0_clk _0136_ VGND VGND VPWR VPWR u_sram.mem\[2\]\[0\] sky130_fd_sc_hd__dfxtp_1
X_1095_ _0313_ _0468_ VGND VGND VPWR VPWR _0469_ sky130_fd_sc_hd__nor2_1
XFILLER_0_35_52 VGND VGND VPWR VPWR sky130_fd_sc_hd__fill_1
X_1164_ _0511_ VGND VGND VPWR VPWR _0103_ sky130_fd_sc_hd__clkbuf_1
X_0948_ net93 _0361_ _0373_ VGND VGND VPWR VPWR _0374_ sky130_fd_sc_hd__mux2_1
XFILLER_0_42_197 VGND VGND VPWR VPWR sky130_fd_sc_hd__fill_2
X_0879_ u_addr_gen.state\[1\] _0302_ VGND VGND VPWR VPWR _0322_ sky130_fd_sc_hd__nand2_1
XFILLER_0_33_164 VGND VGND VPWR VPWR sky130_fd_sc_hd__decap_4
XFILLER_0_33_120 VPWR VGND VPWR VGND sky130_ef_sc_hd__decap_12
XFILLER_0_0_209 VPWR VGND VPWR VGND sky130_ef_sc_hd__decap_12
X_0802_ u_sram.mem\[36\]\[0\] _0174_ _0247_ _0249_ VGND VGND VPWR VPWR _0250_ sky130_fd_sc_hd__a211o_1
X_0733_ u_sram.mem\[37\]\[1\] _0173_ _0176_ _0181_ VGND VGND VPWR VPWR _0182_ sky130_fd_sc_hd__a211o_1
X_0664_ _0564_ VGND VGND VPWR VPWR _0137_ sky130_fd_sc_hd__clkbuf_1
XFILLER_0_24_153 VGND VGND VPWR VPWR sky130_fd_sc_hd__decap_4
X_0595_ _0492_ net95 _0521_ VGND VGND VPWR VPWR _0523_ sky130_fd_sc_hd__mux2_1
X_1216_ clknet_4_15_0_clk _0050_ VGND VGND VPWR VPWR u_sram.mem\[45\]\[0\] sky130_fd_sc_hd__dfxtp_1
XFILLER_0_47_223 VGND VGND VPWR VPWR sky130_fd_sc_hd__fill_1
X_1078_ _0424_ net107 _0457_ VGND VGND VPWR VPWR _0458_ sky130_fd_sc_hd__mux2_1
X_1147_ net46 _0342_ _0500_ VGND VGND VPWR VPWR _0501_ sky130_fd_sc_hd__mux2_1
Xhold11 u_addr_gen.addr\[5\] VGND VGND VPWR VPWR net27 sky130_fd_sc_hd__dlygate4sd3_1
Xhold22 u_sram.mem\[17\]\[0\] VGND VGND VPWR VPWR net38 sky130_fd_sc_hd__dlygate4sd3_1
Xhold99 u_sram.mem\[35\]\[0\] VGND VGND VPWR VPWR net115 sky130_fd_sc_hd__dlygate4sd3_1
Xhold66 u_sram.mem\[44\]\[1\] VGND VGND VPWR VPWR net82 sky130_fd_sc_hd__dlygate4sd3_1
Xhold88 u_sram.mem\[39\]\[0\] VGND VGND VPWR VPWR net104 sky130_fd_sc_hd__dlygate4sd3_1
Xhold33 u_sram.mem\[23\]\[0\] VGND VGND VPWR VPWR net49 sky130_fd_sc_hd__dlygate4sd3_1
Xhold44 u_sram.mem\[51\]\[0\] VGND VGND VPWR VPWR net60 sky130_fd_sc_hd__dlygate4sd3_1
Xhold77 u_sram.mem\[57\]\[1\] VGND VGND VPWR VPWR net93 sky130_fd_sc_hd__dlygate4sd3_1
Xhold55 u_sram.mem\[20\]\[1\] VGND VGND VPWR VPWR net71 sky130_fd_sc_hd__dlygate4sd3_1
XFILLER_0_38_289 VPWR VGND VPWR VGND sky130_ef_sc_hd__decap_12
XTAP_329 VGND VPWR sky130_fd_sc_hd__tapvpwrvgnd_1
XTAP_318 VGND VPWR sky130_fd_sc_hd__tapvpwrvgnd_1
XTAP_307 VGND VPWR sky130_fd_sc_hd__tapvpwrvgnd_1
X_1001_ _0343_ net105 _0408_ VGND VGND VPWR VPWR _0409_ sky130_fd_sc_hd__mux2_1
XFILLER_0_16_76 VGND VGND VPWR VPWR sky130_fd_sc_hd__fill_2
XFILLER_0_4_301 VGND VGND VPWR VPWR sky130_fd_sc_hd__decap_4
XFILLER_0_12_189 VGND VGND VPWR VPWR sky130_fd_sc_hd__decap_6
X_0647_ _0391_ _0520_ VGND VGND VPWR VPWR _0554_ sky130_fd_sc_hd__or2_1
X_0716_ u_sram.addr_r\[5\] u_sram.addr_r\[4\] VGND VGND VPWR VPWR _0165_ sky130_fd_sc_hd__nor2_1
XFILLER_0_32_3 VPWR VGND VPWR VGND sky130_ef_sc_hd__decap_12
XFILLER_0_35_237 VPWR VGND VPWR VGND sky130_ef_sc_hd__decap_12
XFILLER_0_7_150 VGND VGND VPWR VPWR sky130_fd_sc_hd__fill_1
XFILLER_0_43_281 VPWR VGND VPWR VGND sky130_ef_sc_hd__decap_12
XFILLER_0_26_259 VGND VGND VPWR VPWR sky130_fd_sc_hd__fill_1
XTAP_148 VGND VPWR sky130_fd_sc_hd__tapvpwrvgnd_1
XTAP_137 VGND VPWR sky130_fd_sc_hd__tapvpwrvgnd_1
XTAP_126 VGND VPWR sky130_fd_sc_hd__tapvpwrvgnd_1
XTAP_104 VGND VPWR sky130_fd_sc_hd__tapvpwrvgnd_1
XTAP_115 VGND VPWR sky130_fd_sc_hd__tapvpwrvgnd_1
XTAP_159 VGND VPWR sky130_fd_sc_hd__tapvpwrvgnd_1
XFILLER_0_27_97 VGND VGND VPWR VPWR sky130_fd_sc_hd__decap_6
XFILLER_0_43_96 VGND VGND VPWR VPWR sky130_fd_sc_hd__decap_6
XFILLER_0_17_237 VGND VGND VPWR VPWR sky130_fd_sc_hd__decap_8
XFILLER_0_25_281 VPWR VGND VPWR VGND sky130_ef_sc_hd__decap_12
XFILLER_0_40_273 VPWR VGND VPWR VGND sky130_ef_sc_hd__decap_12
X_0981_ _0309_ _0332_ _0335_ VGND VGND VPWR VPWR _0395_ sky130_fd_sc_hd__or3_4
XFILLER_0_22_251 VGND VGND VPWR VPWR sky130_fd_sc_hd__fill_1
XFILLER_0_38_85 VGND VGND VPWR VPWR sky130_fd_sc_hd__decap_8
XFILLER_0_22_284 VGND VGND VPWR VPWR sky130_fd_sc_hd__fill_1
Xhold130 u_sram.mem\[62\]\[0\] VGND VGND VPWR VPWR net146 sky130_fd_sc_hd__dlygate4sd3_1
XFILLER_0_13_284 VGND VGND VPWR VPWR sky130_fd_sc_hd__decap_8
Xhold141 u_sram.mem\[10\]\[0\] VGND VGND VPWR VPWR net157 sky130_fd_sc_hd__dlygate4sd3_1
X_1180_ clknet_4_11_0_clk net21 net13 VGND VGND VPWR VPWR u_fsm.addr_done_seen sky130_fd_sc_hd__dfrtp_1
XFILLER_0_6_204 VGND VGND VPWR VPWR sky130_fd_sc_hd__fill_2
X_0964_ _0317_ _0383_ VGND VGND VPWR VPWR _0384_ sky130_fd_sc_hd__nor2_1
XFILLER_0_49_51 VGND VGND VPWR VPWR sky130_fd_sc_hd__decap_4
X_0895_ _0310_ _0311_ VGND VGND VPWR VPWR _0335_ sky130_fd_sc_hd__nand2_1
XFILLER_0_49_95 VGND VGND VPWR VPWR sky130_fd_sc_hd__decap_3
XFILLER_0_4_97 VPWR VGND VPWR VGND sky130_ef_sc_hd__decap_12
XFILLER_0_4_53 VPWR VGND VPWR VGND sky130_ef_sc_hd__decap_12
XFILLER_0_45_151 VGND VGND VPWR VPWR sky130_fd_sc_hd__fill_2
XFILLER_0_45_140 VGND VGND VPWR VPWR sky130_fd_sc_hd__decap_3
XFILLER_0_5_281 VPWR VGND VPWR VGND sky130_ef_sc_hd__decap_12
Xmax_cap9 _0174_ VGND VGND VPWR VPWR net9 sky130_fd_sc_hd__clkbuf_2
XFILLER_0_24_302 VGND VGND VPWR VPWR sky130_fd_sc_hd__decap_4
XFILLER_0_51_165 VGND VGND VPWR VPWR sky130_fd_sc_hd__decap_3
XFILLER_0_36_195 VGND VGND VPWR VPWR sky130_fd_sc_hd__fill_1
XFILLER_0_10_56 VGND VGND VPWR VPWR sky130_fd_sc_hd__decap_3
XFILLER_0_10_89 VGND VGND VPWR VPWR sky130_fd_sc_hd__fill_1
X_0680_ _0002_ VGND VGND VPWR VPWR _0573_ sky130_fd_sc_hd__inv_2
X_1232_ clknet_4_7_0_clk _0066_ VGND VGND VPWR VPWR u_sram.mem\[37\]\[0\] sky130_fd_sc_hd__dfxtp_1
X_1301_ clknet_4_1_0_clk _0135_ VGND VGND VPWR VPWR u_sram.mem\[2\]\[1\] sky130_fd_sc_hd__dfxtp_1
X_1094_ _0467_ VGND VGND VPWR VPWR _0468_ sky130_fd_sc_hd__buf_2
X_1163_ _0503_ net149 _0510_ VGND VGND VPWR VPWR _0511_ sky130_fd_sc_hd__mux2_1
XFILLER_0_51_85 VPWR VGND VPWR VGND sky130_ef_sc_hd__decap_12
XFILLER_0_51_41 VPWR VGND VPWR VGND sky130_ef_sc_hd__decap_12
X_0947_ _0314_ _0372_ VGND VGND VPWR VPWR _0373_ sky130_fd_sc_hd__nor2_1
XFILLER_0_30_305 VGND VGND VPWR VPWR sky130_fd_sc_hd__fill_1
XFILLER_0_2_251 VGND VGND VPWR VPWR sky130_fd_sc_hd__fill_1
X_0878_ _0321_ VGND VGND VPWR VPWR _0007_ sky130_fd_sc_hd__clkbuf_1
XFILLER_0_33_132 VGND VGND VPWR VPWR sky130_fd_sc_hd__decap_6
XFILLER_0_18_184 VGND VGND VPWR VPWR sky130_fd_sc_hd__decap_3
X_0801_ u_sram.mem\[32\]\[0\] _0164_ _0177_ u_sram.mem\[34\]\[0\] _0248_ VGND VGND
+ VPWR VPWR _0249_ sky130_fd_sc_hd__a221o_1
XFILLER_0_21_11 VGND VGND VPWR VPWR sky130_fd_sc_hd__fill_1
X_0732_ u_sram.mem\[32\]\[1\] _0164_ _0177_ u_sram.mem\[34\]\[1\] _0180_ VGND VGND
+ VPWR VPWR _0181_ sky130_fd_sc_hd__a221o_1
XFILLER_0_12_305 VGND VGND VPWR VPWR sky130_fd_sc_hd__fill_1
X_0594_ _0522_ VGND VGND VPWR VPWR _0109_ sky130_fd_sc_hd__clkbuf_1
X_0663_ _0308_ net133 _0563_ VGND VGND VPWR VPWR _0564_ sky130_fd_sc_hd__mux2_1
XFILLER_0_46_41 VPWR VGND VPWR VGND sky130_ef_sc_hd__decap_12
X_1215_ clknet_4_11_0_clk _0049_ VGND VGND VPWR VPWR u_sram.mem\[45\]\[1\] sky130_fd_sc_hd__dfxtp_1
X_1146_ _0387_ _0468_ VGND VGND VPWR VPWR _0500_ sky130_fd_sc_hd__nor2_1
XFILLER_0_47_279 VGND VGND VPWR VPWR sky130_fd_sc_hd__fill_1
X_1077_ _0399_ _0413_ VGND VGND VPWR VPWR _0457_ sky130_fd_sc_hd__or2_1
Xhold45 u_sram.mem\[40\]\[1\] VGND VGND VPWR VPWR net61 sky130_fd_sc_hd__dlygate4sd3_1
Xhold12 u_comparator.compare_done VGND VGND VPWR VPWR net28 sky130_fd_sc_hd__dlygate4sd3_1
Xhold23 u_sram.mem\[19\]\[0\] VGND VGND VPWR VPWR net39 sky130_fd_sc_hd__dlygate4sd3_1
Xhold56 u_sram.mem\[19\]\[1\] VGND VGND VPWR VPWR net72 sky130_fd_sc_hd__dlygate4sd3_1
Xhold34 u_sram.mem\[21\]\[0\] VGND VGND VPWR VPWR net50 sky130_fd_sc_hd__dlygate4sd3_1
Xhold67 u_sram.mem\[28\]\[0\] VGND VGND VPWR VPWR net83 sky130_fd_sc_hd__dlygate4sd3_1
Xhold78 u_sram.mem\[28\]\[1\] VGND VGND VPWR VPWR net94 sky130_fd_sc_hd__dlygate4sd3_1
Xhold89 u_sram.mem\[48\]\[1\] VGND VGND VPWR VPWR net105 sky130_fd_sc_hd__dlygate4sd3_1
XTAP_319 VGND VPWR sky130_fd_sc_hd__tapvpwrvgnd_1
XTAP_308 VGND VPWR sky130_fd_sc_hd__tapvpwrvgnd_1
XFILLER_0_21_113 VGND VGND VPWR VPWR sky130_fd_sc_hd__fill_1
XFILLER_0_21_124 VGND VGND VPWR VPWR sky130_fd_sc_hd__decap_8
X_1000_ _0317_ _0407_ VGND VGND VPWR VPWR _0408_ sky130_fd_sc_hd__or2_1
XFILLER_0_16_11 VGND VGND VPWR VPWR sky130_fd_sc_hd__fill_1
X_0715_ u_sram.addr_r\[0\] u_sram.addr_r\[1\] u_sram.addr_r\[3\] _0163_ VGND VGND
+ VPWR VPWR _0164_ sky130_fd_sc_hd__nor4_1
XFILLER_0_12_124 VGND VGND VPWR VPWR sky130_fd_sc_hd__fill_1
X_0646_ _0553_ VGND VGND VPWR VPWR _0130_ sky130_fd_sc_hd__clkbuf_1
XFILLER_0_25_3 VPWR VGND VPWR VGND sky130_ef_sc_hd__decap_12
X_1129_ _0489_ VGND VGND VPWR VPWR _0090_ sky130_fd_sc_hd__clkbuf_1
XFILLER_0_35_249 VPWR VGND VPWR VGND sky130_ef_sc_hd__decap_12
XFILLER_0_43_293 VPWR VGND VPWR VGND sky130_ef_sc_hd__decap_12
XFILLER_0_1_305 VGND VGND VPWR VPWR sky130_fd_sc_hd__fill_1
XTAP_149 VGND VPWR sky130_fd_sc_hd__tapvpwrvgnd_1
XTAP_138 VGND VPWR sky130_fd_sc_hd__tapvpwrvgnd_1
XTAP_127 VGND VPWR sky130_fd_sc_hd__tapvpwrvgnd_1
XTAP_105 VGND VPWR sky130_fd_sc_hd__tapvpwrvgnd_1
XTAP_116 VGND VPWR sky130_fd_sc_hd__tapvpwrvgnd_1
XFILLER_0_43_31 VGND VGND VPWR VPWR sky130_fd_sc_hd__fill_1
XFILLER_0_27_54 VGND VGND VPWR VPWR sky130_fd_sc_hd__fill_2
XFILLER_0_27_65 VGND VGND VPWR VPWR sky130_fd_sc_hd__fill_1
XFILLER_0_40_285 VPWR VGND VPWR VGND sky130_ef_sc_hd__decap_12
XFILLER_0_7_75 VGND VGND VPWR VPWR sky130_fd_sc_hd__fill_1
XFILLER_0_25_293 VPWR VGND VPWR VGND sky130_ef_sc_hd__decap_12
X_0629_ _0543_ VGND VGND VPWR VPWR _0123_ sky130_fd_sc_hd__clkbuf_1
XFILLER_0_31_263 VPWR VGND VPWR VGND sky130_ef_sc_hd__decap_12
XFILLER_0_13_23 VGND VGND VPWR VPWR sky130_fd_sc_hd__fill_1
X_0980_ _0394_ VGND VGND VPWR VPWR _0036_ sky130_fd_sc_hd__clkbuf_1
XFILLER_0_1_113 VPWR VGND VPWR VGND sky130_ef_sc_hd__decap_12
XFILLER_0_9_279 VGND VGND VPWR VPWR sky130_fd_sc_hd__fill_1
Xhold120 u_sram.mem\[27\]\[0\] VGND VGND VPWR VPWR net136 sky130_fd_sc_hd__dlygate4sd3_1
Xhold131 u_sram.mem\[55\]\[0\] VGND VGND VPWR VPWR net147 sky130_fd_sc_hd__dlygate4sd3_1
XFILLER_0_0_9 VPWR VGND VPWR VGND sky130_ef_sc_hd__decap_12
Xhold142 u_addr_gen.start VGND VGND VPWR VPWR net158 sky130_fd_sc_hd__dlygate4sd3_1
X_0894_ _0334_ VGND VGND VPWR VPWR _0010_ sky130_fd_sc_hd__clkbuf_1
XFILLER_0_39_160 VGND VGND VPWR VPWR sky130_fd_sc_hd__fill_2
XFILLER_0_40_54 VGND VGND VPWR VPWR sky130_fd_sc_hd__fill_1
X_0963_ _0344_ _0309_ _0332_ VGND VGND VPWR VPWR _0383_ sky130_fd_sc_hd__or3b_4
XFILLER_0_4_65 VPWR VGND VPWR VGND sky130_ef_sc_hd__decap_12
XFILLER_0_5_293 VPWR VGND VPWR VGND sky130_ef_sc_hd__decap_12
XFILLER_0_36_141 VGND VGND VPWR VPWR sky130_fd_sc_hd__fill_2
X_1231_ clknet_4_7_0_clk _0065_ VGND VGND VPWR VPWR u_sram.mem\[37\]\[1\] sky130_fd_sc_hd__dfxtp_1
X_1300_ clknet_4_2_0_clk _0134_ VGND VGND VPWR VPWR u_sram.mem\[3\]\[0\] sky130_fd_sc_hd__dfxtp_1
X_1162_ _0399_ _0468_ VGND VGND VPWR VPWR _0510_ sky130_fd_sc_hd__or2_1
XFILLER_0_51_53 VGND VGND VPWR VPWR sky130_fd_sc_hd__decap_3
X_1093_ _0362_ _0466_ VGND VGND VPWR VPWR _0467_ sky130_fd_sc_hd__or2_1
XFILLER_0_51_97 VPWR VGND VPWR VGND sky130_ef_sc_hd__decap_12
X_0946_ _0332_ _0362_ _0328_ _0309_ VGND VGND VPWR VPWR _0372_ sky130_fd_sc_hd__or4b_2
X_0877_ net79 _0320_ _0318_ VGND VGND VPWR VPWR _0321_ sky130_fd_sc_hd__mux2_1
XFILLER_0_15_303 VGND VGND VPWR VPWR sky130_fd_sc_hd__decap_3
XFILLER_0_33_111 VGND VGND VPWR VPWR sky130_fd_sc_hd__fill_1
XFILLER_0_18_141 VGND VGND VPWR VPWR sky130_fd_sc_hd__decap_6
XFILLER_0_18_152 VPWR VGND VPWR VGND sky130_ef_sc_hd__decap_12
X_0800_ u_sram.mem\[33\]\[0\] _0178_ _0179_ u_sram.mem\[35\]\[0\] VGND VGND VPWR VPWR
+ _0248_ sky130_fd_sc_hd__a22o_1
X_0731_ u_sram.mem\[33\]\[1\] _0178_ _0179_ u_sram.mem\[35\]\[1\] VGND VGND VPWR VPWR
+ _0180_ sky130_fd_sc_hd__a22o_1
X_0593_ _0503_ net97 _0521_ VGND VGND VPWR VPWR _0522_ sky130_fd_sc_hd__mux2_1
X_0662_ _0403_ _0520_ VGND VGND VPWR VPWR _0563_ sky130_fd_sc_hd__or2_1
XFILLER_0_46_53 VPWR VGND VPWR VGND sky130_ef_sc_hd__decap_12
XFILLER_0_1_55 VGND VGND VPWR VPWR sky130_fd_sc_hd__fill_1
X_1214_ clknet_4_11_0_clk _0048_ VGND VGND VPWR VPWR u_sram.mem\[46\]\[0\] sky130_fd_sc_hd__dfxtp_1
X_1145_ _0499_ VGND VGND VPWR VPWR _0096_ sky130_fd_sc_hd__clkbuf_1
X_1076_ _0456_ VGND VGND VPWR VPWR _0070_ sky130_fd_sc_hd__clkbuf_1
XFILLER_0_47_225 VPWR VGND VPWR VGND sky130_ef_sc_hd__decap_12
XFILLER_0_15_111 VGND VGND VPWR VPWR sky130_fd_sc_hd__fill_1
X_0929_ _0351_ net125 _0358_ VGND VGND VPWR VPWR _0360_ sky130_fd_sc_hd__mux2_1
Xhold57 u_sram.mem\[33\]\[1\] VGND VGND VPWR VPWR net73 sky130_fd_sc_hd__dlygate4sd3_1
Xhold68 u_sram.mem\[36\]\[1\] VGND VGND VPWR VPWR net84 sky130_fd_sc_hd__dlygate4sd3_1
Xhold79 u_sram.mem\[15\]\[0\] VGND VGND VPWR VPWR net95 sky130_fd_sc_hd__dlygate4sd3_1
Xhold13 u_sram.mem\[0\]\[1\] VGND VGND VPWR VPWR net29 sky130_fd_sc_hd__dlygate4sd3_1
Xhold46 u_sram.mem\[45\]\[1\] VGND VGND VPWR VPWR net62 sky130_fd_sc_hd__dlygate4sd3_1
Xhold35 u_sram.mem\[58\]\[1\] VGND VGND VPWR VPWR net51 sky130_fd_sc_hd__dlygate4sd3_1
Xhold24 u_sram.mem\[8\]\[0\] VGND VGND VPWR VPWR net40 sky130_fd_sc_hd__dlygate4sd3_1
XFILLER_0_38_247 VGND VGND VPWR VPWR sky130_fd_sc_hd__decap_4
XTAP_309 VGND VPWR sky130_fd_sc_hd__tapvpwrvgnd_1
XFILLER_0_16_67 VGND VGND VPWR VPWR sky130_fd_sc_hd__fill_2
X_0714_ u_sram.addr_r\[2\] VGND VGND VPWR VPWR _0163_ sky130_fd_sc_hd__buf_2
XFILLER_0_12_169 VGND VGND VPWR VPWR sky130_fd_sc_hd__decap_3
X_0645_ _0320_ net128 _0551_ VGND VGND VPWR VPWR _0553_ sky130_fd_sc_hd__mux2_1
X_1059_ _0446_ VGND VGND VPWR VPWR _0063_ sky130_fd_sc_hd__clkbuf_1
XFILLER_0_18_3 VPWR VGND VPWR VGND sky130_ef_sc_hd__decap_12
X_1128_ net43 _0437_ _0487_ VGND VGND VPWR VPWR _0489_ sky130_fd_sc_hd__mux2_1
XFILLER_0_50_209 VPWR VGND VPWR VGND sky130_ef_sc_hd__decap_12
XFILLER_0_43_261 VPWR VGND VPWR VGND sky130_ef_sc_hd__decap_12
XFILLER_0_26_217 VGND VGND VPWR VPWR sky130_fd_sc_hd__decap_6
XFILLER_0_19_291 VPWR VGND VPWR VGND sky130_ef_sc_hd__decap_12
XTAP_139 VGND VPWR sky130_fd_sc_hd__tapvpwrvgnd_1
XTAP_128 VGND VPWR sky130_fd_sc_hd__tapvpwrvgnd_1
XTAP_106 VGND VPWR sky130_fd_sc_hd__tapvpwrvgnd_1
XTAP_117 VGND VPWR sky130_fd_sc_hd__tapvpwrvgnd_1
XFILLER_0_43_54 VGND VGND VPWR VPWR sky130_fd_sc_hd__fill_2
XFILLER_0_43_43 VGND VGND VPWR VPWR sky130_fd_sc_hd__decap_3
XPHY_0 VGND VGND VPWR VPWR sky130_fd_sc_hd__decap_3
XFILLER_0_40_297 VGND VGND VPWR VPWR sky130_fd_sc_hd__decap_8
X_0628_ _0308_ net35 _0542_ VGND VGND VPWR VPWR _0543_ sky130_fd_sc_hd__mux2_1
XFILLER_0_31_275 VGND VGND VPWR VPWR sky130_fd_sc_hd__decap_4
XFILLER_0_7_3 VPWR VGND VPWR VGND sky130_ef_sc_hd__decap_12
XFILLER_0_13_57 VGND VGND VPWR VPWR sky130_fd_sc_hd__decap_4
XFILLER_0_1_125 VPWR VGND VPWR VGND sky130_ef_sc_hd__decap_12
XFILLER_0_1_169 VPWR VGND VPWR VGND sky130_ef_sc_hd__decap_12
XFILLER_0_22_253 VGND VGND VPWR VPWR sky130_fd_sc_hd__decap_8
XFILLER_0_9_225 VGND VGND VPWR VPWR sky130_fd_sc_hd__fill_2
Xhold110 u_sram.mem\[5\]\[1\] VGND VGND VPWR VPWR net126 sky130_fd_sc_hd__dlygate4sd3_1
Xhold121 u_sram.mem\[50\]\[1\] VGND VGND VPWR VPWR net137 sky130_fd_sc_hd__dlygate4sd3_1
Xhold132 u_sram.mem\[6\]\[1\] VGND VGND VPWR VPWR net148 sky130_fd_sc_hd__dlygate4sd3_1
Xhold143 u_sram.mem\[4\]\[1\] VGND VGND VPWR VPWR net159 sky130_fd_sc_hd__dlygate4sd3_1
XFILLER_0_48_194 VGND VGND VPWR VPWR sky130_fd_sc_hd__fill_2
XFILLER_0_36_301 VGND VGND VPWR VPWR sky130_fd_sc_hd__decap_4
XFILLER_0_24_23 VGND VGND VPWR VPWR sky130_fd_sc_hd__fill_2
X_0893_ _0331_ _0333_ VGND VGND VPWR VPWR _0334_ sky130_fd_sc_hd__and2_1
XFILLER_0_6_239 VPWR VGND VPWR VGND sky130_ef_sc_hd__decap_12
X_0962_ _0382_ VGND VGND VPWR VPWR _0030_ sky130_fd_sc_hd__clkbuf_1
XFILLER_0_4_77 VGND VGND VPWR VPWR sky130_fd_sc_hd__decap_6
XFILLER_0_51_189 VGND VGND VPWR VPWR sky130_fd_sc_hd__decap_6
XFILLER_0_19_23 VGND VGND VPWR VPWR sky130_fd_sc_hd__decap_3
X_1230_ clknet_4_7_0_clk _0064_ VGND VGND VPWR VPWR u_sram.mem\[38\]\[0\] sky130_fd_sc_hd__dfxtp_1
X_1092_ u_addr_gen.addr\[5\] net15 u_addr_gen.addr\[4\] VGND VGND VPWR VPWR _0466_
+ sky130_fd_sc_hd__nand3b_4
X_1161_ _0509_ VGND VGND VPWR VPWR _0102_ sky130_fd_sc_hd__clkbuf_1
XFILLER_0_2_253 VPWR VGND VPWR VGND sky130_ef_sc_hd__decap_12
X_0876_ u_pattern_gen.state_r\[0\] VGND VGND VPWR VPWR _0320_ sky130_fd_sc_hd__buf_2
X_0945_ _0371_ VGND VGND VPWR VPWR _0024_ sky130_fd_sc_hd__clkbuf_1
XFILLER_0_48_3 VPWR VGND VPWR VGND sky130_ef_sc_hd__decap_12
XFILLER_0_18_164 VPWR VGND VPWR VGND sky130_ef_sc_hd__decap_12
XFILLER_0_18_197 VGND VGND VPWR VPWR sky130_fd_sc_hd__fill_1
X_0730_ _0171_ _0163_ _0172_ _0170_ VGND VGND VPWR VPWR _0179_ sky130_fd_sc_hd__and4bb_4
X_0661_ _0562_ VGND VGND VPWR VPWR _0136_ sky130_fd_sc_hd__clkbuf_1
X_0592_ _0313_ _0520_ VGND VGND VPWR VPWR _0521_ sky130_fd_sc_hd__or2_1
X_1213_ clknet_4_11_0_clk _0047_ VGND VGND VPWR VPWR u_sram.mem\[46\]\[1\] sky130_fd_sc_hd__dfxtp_1
X_1075_ net115 _0437_ _0454_ VGND VGND VPWR VPWR _0456_ sky130_fd_sc_hd__mux2_1
XFILLER_0_46_65 VPWR VGND VPWR VGND sky130_ef_sc_hd__decap_12
X_1144_ net45 _0350_ _0497_ VGND VGND VPWR VPWR _0499_ sky130_fd_sc_hd__mux2_1
XFILLER_0_47_237 VPWR VGND VPWR VGND sky130_ef_sc_hd__decap_12
X_0928_ _0359_ VGND VGND VPWR VPWR _0019_ sky130_fd_sc_hd__clkbuf_1
X_0859_ _0302_ net20 _0303_ _0305_ net30 VGND VGND VPWR VPWR _0581_ sky130_fd_sc_hd__a32o_1
Xhold58 u_sram.mem\[34\]\[0\] VGND VGND VPWR VPWR net74 sky130_fd_sc_hd__dlygate4sd3_1
Xhold36 u_sram.mem\[54\]\[1\] VGND VGND VPWR VPWR net52 sky130_fd_sc_hd__dlygate4sd3_1
Xhold47 u_sram.mem\[11\]\[0\] VGND VGND VPWR VPWR net63 sky130_fd_sc_hd__dlygate4sd3_1
Xhold14 u_addr_gen.state\[1\] VGND VGND VPWR VPWR net30 sky130_fd_sc_hd__dlygate4sd3_1
Xhold69 u_sram.mem\[22\]\[1\] VGND VGND VPWR VPWR net85 sky130_fd_sc_hd__dlygate4sd3_1
Xhold25 u_sram.mem\[45\]\[0\] VGND VGND VPWR VPWR net41 sky130_fd_sc_hd__dlygate4sd3_1
XFILLER_0_37_281 VPWR VGND VPWR VGND sky130_ef_sc_hd__decap_12
XFILLER_0_32_67 VPWR VGND VPWR VGND sky130_ef_sc_hd__decap_12
X_0644_ _0552_ VGND VGND VPWR VPWR _0129_ sky130_fd_sc_hd__clkbuf_1
X_0713_ _0162_ VGND VGND VPWR VPWR u_sram.read_req sky130_fd_sc_hd__clkbuf_1
XFILLER_0_20_170 VGND VGND VPWR VPWR sky130_fd_sc_hd__fill_2
X_1058_ net90 _0434_ _0445_ VGND VGND VPWR VPWR _0446_ sky130_fd_sc_hd__mux2_1
X_1127_ _0488_ VGND VGND VPWR VPWR _0089_ sky130_fd_sc_hd__clkbuf_1
XFILLER_0_43_273 VGND VGND VPWR VPWR sky130_fd_sc_hd__decap_6
XFILLER_0_7_164 VGND VGND VPWR VPWR sky130_fd_sc_hd__decap_4
XFILLER_0_11_181 VPWR VGND VPWR VGND sky130_ef_sc_hd__decap_12
XFILLER_0_19_270 VGND VGND VPWR VPWR sky130_fd_sc_hd__decap_3
XTAP_129 VGND VPWR sky130_fd_sc_hd__tapvpwrvgnd_1
XTAP_107 VGND VPWR sky130_fd_sc_hd__tapvpwrvgnd_1
XTAP_118 VGND VPWR sky130_fd_sc_hd__tapvpwrvgnd_1
XPHY_1 VGND VGND VPWR VPWR sky130_fd_sc_hd__decap_3
XFILLER_0_7_66 VGND VGND VPWR VPWR sky130_fd_sc_hd__fill_1
X_0627_ _0362_ _0376_ _0519_ VGND VGND VPWR VPWR _0542_ sky130_fd_sc_hd__or3_1
XFILLER_0_30_3 VGND VGND VPWR VPWR sky130_fd_sc_hd__decap_6
XFILLER_0_16_251 VGND VGND VPWR VPWR sky130_fd_sc_hd__fill_1
XFILLER_0_16_273 VGND VGND VPWR VPWR sky130_fd_sc_hd__decap_3
XFILLER_0_1_137 VGND VGND VPWR VPWR sky130_fd_sc_hd__decap_3
XFILLER_0_1_148 VGND VGND VPWR VPWR sky130_fd_sc_hd__decap_6
Xhold100 u_sram.mem\[42\]\[0\] VGND VGND VPWR VPWR net116 sky130_fd_sc_hd__dlygate4sd3_1
Xhold133 u_sram.mem\[18\]\[1\] VGND VGND VPWR VPWR net149 sky130_fd_sc_hd__dlygate4sd3_1
Xhold144 u_sram.mem\[3\]\[0\] VGND VGND VPWR VPWR net160 sky130_fd_sc_hd__dlygate4sd3_1
Xhold122 u_sram.mem\[63\]\[1\] VGND VGND VPWR VPWR net138 sky130_fd_sc_hd__dlygate4sd3_1
Xhold111 u_sram.mem\[46\]\[1\] VGND VGND VPWR VPWR net127 sky130_fd_sc_hd__dlygate4sd3_1
XFILLER_0_0_181 VPWR VGND VPWR VGND sky130_ef_sc_hd__decap_12
XFILLER_0_51_305 VGND VGND VPWR VPWR sky130_fd_sc_hd__fill_1
XFILLER_0_39_195 VGND VGND VPWR VPWR sky130_fd_sc_hd__decap_3
X_0961_ net147 _0366_ _0380_ VGND VGND VPWR VPWR _0382_ sky130_fd_sc_hd__mux2_1
XFILLER_0_24_79 VGND VGND VPWR VPWR sky130_fd_sc_hd__fill_2
XFILLER_0_42_305 VGND VGND VPWR VPWR sky130_fd_sc_hd__fill_1
XFILLER_0_40_34 VPWR VGND VPWR VGND sky130_ef_sc_hd__decap_12
X_0892_ _0310_ _0311_ _0326_ _0332_ VGND VGND VPWR VPWR _0333_ sky130_fd_sc_hd__a31o_1
XFILLER_0_33_305 VGND VGND VPWR VPWR sky130_fd_sc_hd__fill_1
XTAP_290 VGND VPWR sky130_fd_sc_hd__tapvpwrvgnd_1
XFILLER_0_51_113 VPWR VGND VPWR VGND sky130_ef_sc_hd__decap_12
XFILLER_0_10_15 VPWR VGND VPWR VGND sky130_ef_sc_hd__decap_12
X_1091_ _0465_ VGND VGND VPWR VPWR _0076_ sky130_fd_sc_hd__clkbuf_1
X_1160_ net39 _0350_ _0507_ VGND VGND VPWR VPWR _0509_ sky130_fd_sc_hd__mux2_1
XFILLER_0_42_113 VPWR VGND VPWR VGND sky130_ef_sc_hd__decap_12
X_0944_ net56 _0366_ _0369_ VGND VGND VPWR VPWR _0371_ sky130_fd_sc_hd__mux2_1
XFILLER_0_27_121 VGND VGND VPWR VPWR sky130_fd_sc_hd__decap_3
XFILLER_0_42_179 VPWR VGND VPWR VGND sky130_ef_sc_hd__decap_12
X_0875_ _0319_ VGND VGND VPWR VPWR _0006_ sky130_fd_sc_hd__clkbuf_1
XFILLER_0_2_265 VPWR VGND VPWR VGND sky130_ef_sc_hd__decap_12
X_1289_ clknet_4_9_0_clk _0123_ VGND VGND VPWR VPWR u_sram.mem\[8\]\[1\] sky130_fd_sc_hd__dfxtp_1
XFILLER_0_18_176 VGND VGND VPWR VPWR sky130_fd_sc_hd__decap_8
X_0660_ _0320_ net106 _0560_ VGND VGND VPWR VPWR _0562_ sky130_fd_sc_hd__mux2_1
X_0591_ _0362_ _0519_ VGND VGND VPWR VPWR _0520_ sky130_fd_sc_hd__or2_2
XFILLER_0_24_157 VGND VGND VPWR VPWR sky130_fd_sc_hd__fill_1
XFILLER_0_24_179 VGND VGND VPWR VPWR sky130_fd_sc_hd__decap_6
XFILLER_0_46_77 VGND VGND VPWR VPWR sky130_fd_sc_hd__decap_6
X_1212_ clknet_4_6_0_clk _0046_ VGND VGND VPWR VPWR u_sram.mem\[47\]\[0\] sky130_fd_sc_hd__dfxtp_1
X_1074_ _0455_ VGND VGND VPWR VPWR _0069_ sky130_fd_sc_hd__clkbuf_1
XFILLER_0_1_57 VPWR VGND VPWR VGND sky130_ef_sc_hd__decap_12
X_1143_ _0498_ VGND VGND VPWR VPWR _0095_ sky130_fd_sc_hd__clkbuf_1
XFILLER_0_47_249 VPWR VGND VPWR VGND sky130_ef_sc_hd__decap_12
X_0927_ _0343_ net91 _0358_ VGND VGND VPWR VPWR _0359_ sky130_fd_sc_hd__mux2_1
XFILLER_0_15_113 VPWR VGND VPWR VGND sky130_ef_sc_hd__decap_12
X_0789_ u_sram.mem\[45\]\[1\] _0168_ _0207_ VGND VGND VPWR VPWR _0238_ sky130_fd_sc_hd__and3_1
X_0858_ u_addr_gen.addr\[4\] u_addr_gen.addr\[5\] _0151_ _0304_ VGND VGND VPWR VPWR
+ _0305_ sky130_fd_sc_hd__and4_1
Xhold59 u_sram.mem\[53\]\[0\] VGND VGND VPWR VPWR net75 sky130_fd_sc_hd__dlygate4sd3_1
Xhold48 u_sram.mem\[7\]\[1\] VGND VGND VPWR VPWR net64 sky130_fd_sc_hd__dlygate4sd3_1
Xhold26 u_sram.mem\[61\]\[1\] VGND VGND VPWR VPWR net42 sky130_fd_sc_hd__dlygate4sd3_1
Xhold37 u_sram.mem\[1\]\[0\] VGND VGND VPWR VPWR net53 sky130_fd_sc_hd__dlygate4sd3_1
Xhold15 u_addr_gen.addr_valid VGND VGND VPWR VPWR net31 sky130_fd_sc_hd__dlygate4sd3_1
XFILLER_0_21_105 VGND VGND VPWR VPWR sky130_fd_sc_hd__decap_6
XFILLER_0_21_138 VGND VGND VPWR VPWR sky130_fd_sc_hd__decap_3
XFILLER_0_37_293 VPWR VGND VPWR VGND sky130_ef_sc_hd__decap_12
XFILLER_0_32_79 VGND VGND VPWR VPWR sky130_fd_sc_hd__decap_4
XFILLER_0_4_305 VGND VGND VPWR VPWR sky130_fd_sc_hd__fill_1
XFILLER_0_29_249 VGND VGND VPWR VPWR sky130_fd_sc_hd__fill_2
XFILLER_0_12_138 VGND VGND VPWR VPWR sky130_fd_sc_hd__fill_2
XFILLER_0_12_149 VPWR VGND VPWR VGND sky130_ef_sc_hd__decap_12
X_0643_ _0308_ net126 _0551_ VGND VGND VPWR VPWR _0552_ sky130_fd_sc_hd__mux2_1
X_0712_ net31 _0148_ VGND VGND VPWR VPWR _0162_ sky130_fd_sc_hd__and2_1
X_1126_ net122 _0434_ _0487_ VGND VGND VPWR VPWR _0488_ sky130_fd_sc_hd__mux2_1
X_1057_ _0383_ _0413_ VGND VGND VPWR VPWR _0445_ sky130_fd_sc_hd__nor2_1
XFILLER_0_7_176 VPWR VGND VPWR VGND sky130_ef_sc_hd__decap_12
XFILLER_0_22_90 VGND VGND VPWR VPWR sky130_fd_sc_hd__decap_8
XFILLER_0_11_193 VGND VGND VPWR VPWR sky130_fd_sc_hd__decap_4
XPHY_100 VGND VGND VPWR VPWR sky130_fd_sc_hd__decap_3
XFILLER_0_34_230 VPWR VGND VPWR VGND sky130_ef_sc_hd__decap_12
XFILLER_0_34_263 VPWR VGND VPWR VGND sky130_ef_sc_hd__decap_12
XTAP_119 VGND VPWR sky130_fd_sc_hd__tapvpwrvgnd_1
XTAP_108 VGND VPWR sky130_fd_sc_hd__tapvpwrvgnd_1
XFILLER_0_27_35 VGND VGND VPWR VPWR sky130_fd_sc_hd__decap_3
XPHY_2 VGND VGND VPWR VPWR sky130_fd_sc_hd__decap_3
Xclkbuf_0_clk clk VGND VGND VPWR VPWR clknet_0_clk sky130_fd_sc_hd__clkbuf_16
XFILLER_0_4_135 VGND VGND VPWR VPWR sky130_fd_sc_hd__decap_4
X_0626_ _0541_ VGND VGND VPWR VPWR _0122_ sky130_fd_sc_hd__clkbuf_1
X_1109_ _0477_ VGND VGND VPWR VPWR _0082_ sky130_fd_sc_hd__clkbuf_1
XFILLER_0_23_3 VPWR VGND VPWR VGND sky130_ef_sc_hd__decap_12
XFILLER_0_31_233 VGND VGND VPWR VPWR sky130_fd_sc_hd__decap_8
XFILLER_0_13_15 VGND VGND VPWR VPWR sky130_fd_sc_hd__decap_8
XFILLER_0_13_48 VGND VGND VPWR VPWR sky130_fd_sc_hd__decap_3
XFILLER_0_1_105 VGND VGND VPWR VPWR sky130_fd_sc_hd__decap_6
XFILLER_0_22_222 VGND VGND VPWR VPWR sky130_fd_sc_hd__decap_4
XFILLER_0_38_78 VGND VGND VPWR VPWR sky130_fd_sc_hd__decap_6
XFILLER_0_38_45 VGND VGND VPWR VPWR sky130_fd_sc_hd__fill_2
XFILLER_0_38_23 VGND VGND VPWR VPWR sky130_fd_sc_hd__fill_2
Xhold101 u_sram.mem\[37\]\[0\] VGND VGND VPWR VPWR net117 sky130_fd_sc_hd__dlygate4sd3_1
Xhold123 u_sram.mem\[35\]\[1\] VGND VGND VPWR VPWR net139 sky130_fd_sc_hd__dlygate4sd3_1
Xhold134 u_sram.mem\[6\]\[0\] VGND VGND VPWR VPWR net150 sky130_fd_sc_hd__dlygate4sd3_1
Xhold112 u_sram.mem\[5\]\[0\] VGND VGND VPWR VPWR net128 sky130_fd_sc_hd__dlygate4sd3_1
Xhold145 net4 VGND VGND VPWR VPWR net161 sky130_fd_sc_hd__dlygate4sd3_1
XFILLER_0_0_193 VGND VGND VPWR VPWR sky130_fd_sc_hd__decap_3
X_0609_ _0531_ VGND VGND VPWR VPWR _0115_ sky130_fd_sc_hd__clkbuf_1
XFILLER_0_39_152 VGND VGND VPWR VPWR sky130_fd_sc_hd__decap_8
X_0960_ _0381_ VGND VGND VPWR VPWR _0029_ sky130_fd_sc_hd__clkbuf_1
XFILLER_0_49_55 VGND VGND VPWR VPWR sky130_fd_sc_hd__fill_1
XFILLER_0_40_79 VGND VGND VPWR VPWR sky130_fd_sc_hd__fill_2
XFILLER_0_40_46 VGND VGND VPWR VPWR sky130_fd_sc_hd__decap_8
X_0891_ u_addr_gen.addr\[2\] VGND VGND VPWR VPWR _0332_ sky130_fd_sc_hd__buf_2
XFILLER_0_5_241 VPWR VGND VPWR VGND sky130_ef_sc_hd__decap_12
XFILLER_0_14_80 VGND VGND VPWR VPWR sky130_fd_sc_hd__decap_4
XFILLER_0_18_303 VGND VGND VPWR VPWR sky130_fd_sc_hd__decap_3
XTAP_291 VGND VPWR sky130_fd_sc_hd__tapvpwrvgnd_1
XTAP_280 VGND VPWR sky130_fd_sc_hd__tapvpwrvgnd_1
XFILLER_0_51_169 VPWR VGND VPWR VGND sky130_ef_sc_hd__decap_12
XFILLER_0_51_125 VPWR VGND VPWR VGND sky130_ef_sc_hd__decap_12
XFILLER_0_10_27 VGND VGND VPWR VPWR sky130_fd_sc_hd__fill_1
X_1090_ _0422_ net89 _0463_ VGND VGND VPWR VPWR _0465_ sky130_fd_sc_hd__mux2_1
XFILLER_0_35_68 VGND VGND VPWR VPWR sky130_fd_sc_hd__decap_4
XFILLER_0_35_46 VGND VGND VPWR VPWR sky130_fd_sc_hd__decap_6
XFILLER_0_35_35 VGND VGND VPWR VPWR sky130_fd_sc_hd__fill_2
XFILLER_0_42_125 VGND VGND VPWR VPWR sky130_fd_sc_hd__fill_2
XFILLER_0_42_103 VGND VGND VPWR VPWR sky130_fd_sc_hd__fill_2
X_0874_ net138 _0308_ _0318_ VGND VGND VPWR VPWR _0319_ sky130_fd_sc_hd__mux2_1
X_0943_ _0370_ VGND VGND VPWR VPWR _0023_ sky130_fd_sc_hd__clkbuf_1
XFILLER_0_2_277 VPWR VGND VPWR VGND sky130_ef_sc_hd__decap_12
X_1288_ clknet_4_1_0_clk _0122_ VGND VGND VPWR VPWR u_sram.mem\[9\]\[0\] sky130_fd_sc_hd__dfxtp_1
XFILLER_0_18_133 VGND VGND VPWR VPWR sky130_fd_sc_hd__decap_6
X_0590_ u_addr_gen.addr\[4\] u_addr_gen.addr\[5\] net14 VGND VGND VPWR VPWR _0519_
+ sky130_fd_sc_hd__or3b_4
X_1211_ clknet_4_6_0_clk _0045_ VGND VGND VPWR VPWR u_sram.mem\[47\]\[1\] sky130_fd_sc_hd__dfxtp_1
X_1142_ net85 _0342_ _0497_ VGND VGND VPWR VPWR _0498_ sky130_fd_sc_hd__mux2_1
X_1073_ net139 _0434_ _0454_ VGND VGND VPWR VPWR _0455_ sky130_fd_sc_hd__mux2_1
XFILLER_0_1_69 VPWR VGND VPWR VGND sky130_ef_sc_hd__decap_12
X_0857_ u_addr_gen.addr\[0\] u_addr_gen.addr\[1\] u_addr_gen.addr\[3\] u_addr_gen.addr\[2\]
+ VGND VGND VPWR VPWR _0304_ sky130_fd_sc_hd__and4_1
XFILLER_0_15_125 VGND VGND VPWR VPWR sky130_fd_sc_hd__decap_8
XFILLER_0_15_169 VGND VGND VPWR VPWR sky130_fd_sc_hd__fill_2
X_0926_ _0314_ _0357_ VGND VGND VPWR VPWR _0358_ sky130_fd_sc_hd__or2_1
Xhold38 u_sram.mem\[39\]\[1\] VGND VGND VPWR VPWR net54 sky130_fd_sc_hd__dlygate4sd3_1
Xhold16 u_sram.mem\[43\]\[0\] VGND VGND VPWR VPWR net32 sky130_fd_sc_hd__dlygate4sd3_1
Xhold27 u_sram.mem\[25\]\[0\] VGND VGND VPWR VPWR net43 sky130_fd_sc_hd__dlygate4sd3_1
X_0788_ u_sram.mem\[30\]\[1\] _0203_ _0184_ VGND VGND VPWR VPWR _0237_ sky130_fd_sc_hd__and3_1
XFILLER_0_30_139 VGND VGND VPWR VPWR sky130_fd_sc_hd__fill_1
Xhold49 u_sram.mem\[11\]\[1\] VGND VGND VPWR VPWR net65 sky130_fd_sc_hd__dlygate4sd3_1
XFILLER_0_46_250 VGND VGND VPWR VPWR sky130_fd_sc_hd__fill_2
XFILLER_0_44_209 VPWR VGND VPWR VGND sky130_ef_sc_hd__decap_12
X_0711_ _0161_ VGND VGND VPWR VPWR u_comparator.enable sky130_fd_sc_hd__clkbuf_1
XFILLER_0_12_128 VGND VGND VPWR VPWR sky130_fd_sc_hd__fill_1
X_0642_ _0387_ _0520_ VGND VGND VPWR VPWR _0551_ sky130_fd_sc_hd__or2_1
X_1125_ _0372_ _0466_ VGND VGND VPWR VPWR _0487_ sky130_fd_sc_hd__nor2_1
X_1056_ _0444_ VGND VGND VPWR VPWR _0062_ sky130_fd_sc_hd__clkbuf_1
XFILLER_0_7_144 VGND VGND VPWR VPWR sky130_fd_sc_hd__decap_6
XFILLER_0_7_111 VGND VGND VPWR VPWR sky130_fd_sc_hd__fill_1
XFILLER_0_28_250 VGND VGND VPWR VPWR sky130_fd_sc_hd__fill_2
X_0909_ u_addr_gen.addr\[3\] u_addr_gen.addr\[2\] VGND VGND VPWR VPWR _0345_ sky130_fd_sc_hd__nand2_1
XFILLER_0_7_188 VPWR VGND VPWR VGND sky130_ef_sc_hd__decap_12
XFILLER_0_11_161 VGND VGND VPWR VPWR sky130_fd_sc_hd__decap_6
XPHY_101 VGND VGND VPWR VPWR sky130_fd_sc_hd__decap_3
XFILLER_0_34_275 VPWR VGND VPWR VGND sky130_ef_sc_hd__decap_12
XFILLER_0_34_242 VGND VGND VPWR VPWR sky130_fd_sc_hd__decap_6
XTAP_109 VGND VPWR sky130_fd_sc_hd__tapvpwrvgnd_1
XFILLER_0_43_57 VGND VGND VPWR VPWR sky130_fd_sc_hd__decap_3
XFILLER_0_43_35 VGND VGND VPWR VPWR sky130_fd_sc_hd__decap_8
XPHY_3 VGND VGND VPWR VPWR sky130_fd_sc_hd__decap_3
XFILLER_0_17_209 VPWR VGND VPWR VGND sky130_ef_sc_hd__decap_12
X_0625_ _0320_ net108 _0539_ VGND VGND VPWR VPWR _0541_ sky130_fd_sc_hd__mux2_1
XFILLER_0_25_231 VPWR VGND VPWR VGND sky130_ef_sc_hd__decap_12
XFILLER_0_48_301 VGND VGND VPWR VPWR sky130_fd_sc_hd__decap_4
X_1108_ _0422_ net141 _0475_ VGND VGND VPWR VPWR _0477_ sky130_fd_sc_hd__mux2_1
X_1039_ _0433_ VGND VGND VPWR VPWR _0056_ sky130_fd_sc_hd__clkbuf_1
XFILLER_0_16_3 VGND VGND VPWR VPWR sky130_fd_sc_hd__decap_8
XFILLER_0_16_231 VPWR VGND VPWR VGND sky130_ef_sc_hd__decap_12
XFILLER_0_22_212 VGND VGND VPWR VPWR sky130_fd_sc_hd__fill_1
Xhold102 u_sram.mem\[53\]\[1\] VGND VGND VPWR VPWR net118 sky130_fd_sc_hd__dlygate4sd3_1
Xhold135 u_sram.mem\[48\]\[0\] VGND VGND VPWR VPWR net151 sky130_fd_sc_hd__dlygate4sd3_1
Xhold113 u_sram.mem\[49\]\[0\] VGND VGND VPWR VPWR net129 sky130_fd_sc_hd__dlygate4sd3_1
X_0608_ _0503_ net130 _0530_ VGND VGND VPWR VPWR _0531_ sky130_fd_sc_hd__mux2_1
XFILLER_0_13_278 VGND VGND VPWR VPWR sky130_fd_sc_hd__fill_2
Xhold124 u_sram.mem\[13\]\[1\] VGND VGND VPWR VPWR net140 sky130_fd_sc_hd__dlygate4sd3_1
XFILLER_0_8_261 VGND VGND VPWR VPWR sky130_fd_sc_hd__fill_2
XFILLER_0_8_283 VPWR VGND VPWR VGND sky130_ef_sc_hd__decap_12
XFILLER_0_5_3 VPWR VGND VPWR VGND sky130_ef_sc_hd__decap_12
XFILLER_0_24_15 VGND VGND VPWR VPWR sky130_fd_sc_hd__decap_8
XFILLER_0_24_37 VGND VGND VPWR VPWR sky130_fd_sc_hd__fill_2
XFILLER_0_39_175 VPWR VGND VPWR VGND sky130_ef_sc_hd__decap_12
X_0890_ _0312_ _0322_ _0326_ VGND VGND VPWR VPWR _0331_ sky130_fd_sc_hd__o21ai_1
XFILLER_0_10_226 VGND VGND VPWR VPWR sky130_fd_sc_hd__decap_8
XFILLER_0_49_89 VGND VGND VPWR VPWR sky130_fd_sc_hd__decap_3
XFILLER_0_5_253 VPWR VGND VPWR VGND sky130_ef_sc_hd__decap_12
XTAP_292 VGND VPWR sky130_fd_sc_hd__tapvpwrvgnd_1
XTAP_281 VGND VPWR sky130_fd_sc_hd__tapvpwrvgnd_1
XTAP_270 VGND VPWR sky130_fd_sc_hd__tapvpwrvgnd_1
XFILLER_0_51_137 VGND VGND VPWR VPWR sky130_fd_sc_hd__decap_3
XFILLER_0_19_15 VGND VGND VPWR VPWR sky130_fd_sc_hd__decap_8
XFILLER_0_51_57 VPWR VGND VPWR VGND sky130_ef_sc_hd__decap_12
X_0873_ _0313_ _0317_ VGND VGND VPWR VPWR _0318_ sky130_fd_sc_hd__nor2_1
X_0942_ net51 _0361_ _0369_ VGND VGND VPWR VPWR _0370_ sky130_fd_sc_hd__mux2_1
XFILLER_0_50_181 VPWR VGND VPWR VGND sky130_ef_sc_hd__decap_12
XFILLER_0_2_289 VPWR VGND VPWR VGND sky130_ef_sc_hd__decap_12
X_1287_ clknet_4_1_0_clk _0121_ VGND VGND VPWR VPWR u_sram.mem\[9\]\[1\] sky130_fd_sc_hd__dfxtp_1
XFILLER_0_49_281 VPWR VGND VPWR VGND sky130_ef_sc_hd__decap_12
X_1072_ _0395_ _0413_ VGND VGND VPWR VPWR _0454_ sky130_fd_sc_hd__nor2_1
X_1210_ clknet_4_10_0_clk _0044_ VGND VGND VPWR VPWR u_sram.mem\[48\]\[0\] sky130_fd_sc_hd__dfxtp_1
XFILLER_0_1_15 VPWR VGND VPWR VGND sky130_ef_sc_hd__decap_12
X_1141_ _0383_ _0468_ VGND VGND VPWR VPWR _0497_ sky130_fd_sc_hd__nor2_1
XFILLER_0_47_207 VPWR VGND VPWR VGND sky130_ef_sc_hd__decap_12
X_0925_ _0310_ _0311_ _0346_ VGND VGND VPWR VPWR _0357_ sky130_fd_sc_hd__or3_2
XFILLER_0_11_71 VPWR VGND VPWR VGND sky130_ef_sc_hd__decap_12
X_0787_ u_sram.mem\[43\]\[1\] _0169_ _0210_ _0234_ _0235_ VGND VGND VPWR VPWR _0236_
+ sky130_fd_sc_hd__a311o_1
X_0856_ u_addr_gen.state\[1\] u_addr_gen.state\[0\] VGND VGND VPWR VPWR _0303_ sky130_fd_sc_hd__or2_1
XFILLER_0_46_3 VPWR VGND VPWR VGND sky130_ef_sc_hd__decap_12
Xhold39 u_sram.mem\[51\]\[1\] VGND VGND VPWR VPWR net55 sky130_fd_sc_hd__dlygate4sd3_1
Xhold17 u_sram.mem\[41\]\[0\] VGND VGND VPWR VPWR net33 sky130_fd_sc_hd__dlygate4sd3_1
Xhold28 u_sram.mem\[16\]\[1\] VGND VGND VPWR VPWR net44 sky130_fd_sc_hd__dlygate4sd3_1
XFILLER_0_32_15 VPWR VGND VPWR VGND sky130_ef_sc_hd__decap_12
X_0641_ _0550_ VGND VGND VPWR VPWR _0128_ sky130_fd_sc_hd__clkbuf_1
XFILLER_0_12_118 VGND VGND VPWR VPWR sky130_fd_sc_hd__decap_6
X_0710_ u_fsm.state\[2\] u_fsm.rvalid _0149_ VGND VGND VPWR VPWR _0161_ sky130_fd_sc_hd__and3_1
XFILLER_0_20_184 VPWR VGND VPWR VGND sky130_ef_sc_hd__decap_12
X_1124_ _0486_ VGND VGND VPWR VPWR _0088_ sky130_fd_sc_hd__clkbuf_1
X_1055_ net104 _0437_ _0442_ VGND VGND VPWR VPWR _0444_ sky130_fd_sc_hd__mux2_1
XFILLER_0_43_221 VGND VGND VPWR VPWR sky130_fd_sc_hd__decap_3
X_0908_ u_addr_gen.addr\[0\] _0311_ VGND VGND VPWR VPWR _0344_ sky130_fd_sc_hd__or2b_1
X_0839_ u_sram.mem\[4\]\[0\] net8 _0286_ VGND VGND VPWR VPWR _0287_ sky130_fd_sc_hd__a21o_1
XPHY_102 VGND VGND VPWR VPWR sky130_fd_sc_hd__decap_3
XFILLER_0_34_287 VPWR VGND VPWR VGND sky130_ef_sc_hd__decap_12
XFILLER_0_34_210 VGND VGND VPWR VPWR sky130_fd_sc_hd__fill_2
XFILLER_0_27_15 VPWR VGND VPWR VGND sky130_ef_sc_hd__decap_12
XPHY_4 VGND VGND VPWR VPWR sky130_fd_sc_hd__decap_3
XFILLER_0_25_243 VPWR VGND VPWR VGND sky130_ef_sc_hd__decap_12
XFILLER_0_40_224 VGND VGND VPWR VPWR sky130_fd_sc_hd__fill_1
X_0624_ _0540_ VGND VGND VPWR VPWR _0121_ sky130_fd_sc_hd__clkbuf_1
X_1107_ _0476_ VGND VGND VPWR VPWR _0081_ sky130_fd_sc_hd__clkbuf_1
X_1038_ net116 _0366_ _0431_ VGND VGND VPWR VPWR _0433_ sky130_fd_sc_hd__mux2_1
XFILLER_0_31_202 VGND VGND VPWR VPWR sky130_fd_sc_hd__fill_1
XFILLER_0_16_243 VGND VGND VPWR VPWR sky130_fd_sc_hd__fill_1
XFILLER_0_31_279 VGND VGND VPWR VPWR sky130_fd_sc_hd__fill_1
XFILLER_0_45_305 VGND VGND VPWR VPWR sky130_fd_sc_hd__fill_1
Xhold125 u_sram.mem\[29\]\[0\] VGND VGND VPWR VPWR net141 sky130_fd_sc_hd__dlygate4sd3_1
Xhold103 u_sram.mem\[47\]\[1\] VGND VGND VPWR VPWR net119 sky130_fd_sc_hd__dlygate4sd3_1
Xhold136 u_sram.mem\[3\]\[1\] VGND VGND VPWR VPWR net152 sky130_fd_sc_hd__dlygate4sd3_1
Xhold114 u_sram.mem\[12\]\[1\] VGND VGND VPWR VPWR net130 sky130_fd_sc_hd__dlygate4sd3_1
X_0607_ _0357_ _0519_ VGND VGND VPWR VPWR _0530_ sky130_fd_sc_hd__or2_1
XFILLER_0_36_305 VGND VGND VPWR VPWR sky130_fd_sc_hd__fill_1
XFILLER_0_8_295 VGND VGND VPWR VPWR sky130_fd_sc_hd__decap_8
XFILLER_0_39_187 VGND VGND VPWR VPWR sky130_fd_sc_hd__decap_8
XFILLER_0_40_15 VPWR VGND VPWR VGND sky130_ef_sc_hd__decap_12
XFILLER_0_27_305 VGND VGND VPWR VPWR sky130_fd_sc_hd__fill_1
XFILLER_0_49_57 VPWR VGND VPWR VGND sky130_ef_sc_hd__decap_12
XFILLER_0_4_15 VPWR VGND VPWR VGND sky130_ef_sc_hd__decap_12
XFILLER_0_10_249 VGND VGND VPWR VPWR sky130_fd_sc_hd__decap_3
XFILLER_0_5_265 VPWR VGND VPWR VGND sky130_ef_sc_hd__decap_12
XTAP_293 VGND VPWR sky130_fd_sc_hd__tapvpwrvgnd_1
XTAP_282 VGND VPWR sky130_fd_sc_hd__tapvpwrvgnd_1
XTAP_271 VGND VPWR sky130_fd_sc_hd__tapvpwrvgnd_1
XTAP_260 VGND VPWR sky130_fd_sc_hd__tapvpwrvgnd_1
XFILLER_0_36_102 VGND VGND VPWR VPWR sky130_fd_sc_hd__fill_1
XFILLER_0_35_15 VPWR VGND VPWR VGND sky130_ef_sc_hd__decap_12
XFILLER_0_51_69 VPWR VGND VPWR VGND sky130_ef_sc_hd__decap_12
X_0941_ _0314_ _0368_ VGND VGND VPWR VPWR _0369_ sky130_fd_sc_hd__nor2_1
XFILLER_0_27_113 VGND VGND VPWR VPWR sky130_fd_sc_hd__decap_8
XFILLER_0_35_190 VGND VGND VPWR VPWR sky130_fd_sc_hd__fill_2
X_0872_ _0316_ VGND VGND VPWR VPWR _0317_ sky130_fd_sc_hd__buf_2
XFILLER_0_27_157 VGND VGND VPWR VPWR sky130_fd_sc_hd__fill_2
XFILLER_0_50_193 VGND VGND VPWR VPWR sky130_fd_sc_hd__decap_3
X_1286_ clknet_4_1_0_clk _0120_ VGND VGND VPWR VPWR u_sram.mem\[10\]\[0\] sky130_fd_sc_hd__dfxtp_1
XFILLER_0_25_81 VGND VGND VPWR VPWR sky130_fd_sc_hd__decap_6
XFILLER_0_33_105 VGND VGND VPWR VPWR sky130_fd_sc_hd__decap_6
XFILLER_0_41_160 VGND VGND VPWR VPWR sky130_fd_sc_hd__fill_1
XFILLER_0_33_138 VGND VGND VPWR VPWR sky130_fd_sc_hd__fill_1
XFILLER_0_49_293 VPWR VGND VPWR VGND sky130_ef_sc_hd__decap_12
XFILLER_0_21_39 VPWR VGND VPWR VGND sky130_ef_sc_hd__decap_12
X_1071_ _0453_ VGND VGND VPWR VPWR _0068_ sky130_fd_sc_hd__clkbuf_1
X_1140_ _0496_ VGND VGND VPWR VPWR _0094_ sky130_fd_sc_hd__clkbuf_1
XFILLER_0_1_27 VPWR VGND VPWR VGND sky130_ef_sc_hd__decap_12
XFILLER_0_47_219 VGND VGND VPWR VPWR sky130_fd_sc_hd__decap_4
XFILLER_0_7_305 VGND VGND VPWR VPWR sky130_fd_sc_hd__fill_1
X_0924_ _0356_ VGND VGND VPWR VPWR _0018_ sky130_fd_sc_hd__clkbuf_1
XFILLER_0_11_83 VGND VGND VPWR VPWR sky130_fd_sc_hd__decap_4
X_0786_ u_sram.mem\[19\]\[1\] _0179_ _0185_ VGND VGND VPWR VPWR _0235_ sky130_fd_sc_hd__and3_1
X_0855_ u_addr_gen.start VGND VGND VPWR VPWR _0302_ sky130_fd_sc_hd__inv_2
XFILLER_0_39_3 VPWR VGND VPWR VGND sky130_ef_sc_hd__decap_12
Xhold18 u_fsm.rvalid VGND VGND VPWR VPWR net34 sky130_fd_sc_hd__dlygate4sd3_1
Xhold29 u_sram.mem\[22\]\[0\] VGND VGND VPWR VPWR net45 sky130_fd_sc_hd__dlygate4sd3_1
XFILLER_0_36_80 VGND VGND VPWR VPWR sky130_fd_sc_hd__decap_4
X_1269_ clknet_4_4_0_clk _0103_ VGND VGND VPWR VPWR u_sram.mem\[18\]\[1\] sky130_fd_sc_hd__dfxtp_1
XFILLER_0_46_230 VPWR VGND VPWR VGND sky130_ef_sc_hd__decap_12
XFILLER_0_32_27 VGND VGND VPWR VPWR sky130_fd_sc_hd__fill_1
X_0640_ _0320_ net150 _0548_ VGND VGND VPWR VPWR _0550_ sky130_fd_sc_hd__mux2_1
XFILLER_0_20_130 VGND VGND VPWR VPWR sky130_fd_sc_hd__fill_1
XFILLER_0_20_141 VGND VGND VPWR VPWR sky130_fd_sc_hd__decap_4
X_1123_ net135 _0437_ _0484_ VGND VGND VPWR VPWR _0486_ sky130_fd_sc_hd__mux2_1
X_1054_ _0443_ VGND VGND VPWR VPWR _0061_ sky130_fd_sc_hd__clkbuf_1
XFILLER_0_7_157 VGND VGND VPWR VPWR sky130_fd_sc_hd__decap_4
X_0907_ _0342_ VGND VGND VPWR VPWR _0343_ sky130_fd_sc_hd__buf_2
XFILLER_0_22_82 VGND VGND VPWR VPWR sky130_fd_sc_hd__fill_2
X_0769_ u_sram.mem\[55\]\[1\] _0194_ _0217_ VGND VGND VPWR VPWR _0218_ sky130_fd_sc_hd__a21o_1
X_0838_ u_sram.mem\[12\]\[0\] _0200_ _0194_ u_sram.mem\[7\]\[0\] VGND VGND VPWR VPWR
+ _0286_ sky130_fd_sc_hd__a22o_1
XPHY_103 VGND VGND VPWR VPWR sky130_fd_sc_hd__decap_3
XFILLER_0_34_299 VGND VGND VPWR VPWR sky130_fd_sc_hd__decap_6
XFILLER_0_27_27 VGND VGND VPWR VPWR sky130_fd_sc_hd__decap_8
XFILLER_0_43_15 VPWR VGND VPWR VGND sky130_ef_sc_hd__decap_12
XPHY_5 VGND VGND VPWR VPWR sky130_fd_sc_hd__decap_3
XFILLER_0_25_200 VGND VGND VPWR VPWR sky130_fd_sc_hd__decap_6
XFILLER_0_25_255 VGND VGND VPWR VPWR sky130_fd_sc_hd__decap_4
XFILLER_0_7_15 VPWR VGND VPWR VGND sky130_ef_sc_hd__decap_12
X_0623_ _0503_ net86 _0539_ VGND VGND VPWR VPWR _0540_ sky130_fd_sc_hd__mux2_1
X_1106_ _0424_ net121 _0475_ VGND VGND VPWR VPWR _0476_ sky130_fd_sc_hd__mux2_1
X_1037_ _0432_ VGND VGND VPWR VPWR _0055_ sky130_fd_sc_hd__clkbuf_1
XFILLER_0_33_81 VPWR VGND VPWR VGND sky130_ef_sc_hd__decap_12
XFILLER_0_38_15 VGND VGND VPWR VPWR sky130_fd_sc_hd__decap_8
Xhold115 u_sram.mem\[33\]\[0\] VGND VGND VPWR VPWR net131 sky130_fd_sc_hd__dlygate4sd3_1
Xhold104 u_sram.mem\[18\]\[0\] VGND VGND VPWR VPWR net120 sky130_fd_sc_hd__dlygate4sd3_1
XFILLER_0_13_225 VGND VGND VPWR VPWR sky130_fd_sc_hd__fill_2
XFILLER_0_13_258 VPWR VGND VPWR VGND sky130_ef_sc_hd__decap_12
Xhold126 u_sram.mem\[14\]\[0\] VGND VGND VPWR VPWR net142 sky130_fd_sc_hd__dlygate4sd3_1
Xhold137 u_sram.mem\[47\]\[0\] VGND VGND VPWR VPWR net153 sky130_fd_sc_hd__dlygate4sd3_1
XFILLER_0_0_141 VPWR VGND VPWR VGND sky130_ef_sc_hd__decap_12
X_0606_ _0529_ VGND VGND VPWR VPWR _0114_ sky130_fd_sc_hd__clkbuf_1
XFILLER_0_21_3 VGND VGND VPWR VPWR sky130_fd_sc_hd__decap_8
XFILLER_0_48_144 VGND VGND VPWR VPWR sky130_fd_sc_hd__fill_2
XFILLER_0_39_166 VGND VGND VPWR VPWR sky130_fd_sc_hd__fill_2
XFILLER_0_40_27 VGND VGND VPWR VPWR sky130_fd_sc_hd__fill_1
XFILLER_0_49_69 VPWR VGND VPWR VGND sky130_ef_sc_hd__decap_12
XFILLER_0_4_27 VGND VGND VPWR VPWR sky130_fd_sc_hd__fill_1
XFILLER_0_45_169 VGND VGND VPWR VPWR sky130_fd_sc_hd__decap_3
XFILLER_0_5_277 VGND VGND VPWR VPWR sky130_fd_sc_hd__decap_3
XTAP_294 VGND VPWR sky130_fd_sc_hd__tapvpwrvgnd_1
XTAP_283 VGND VPWR sky130_fd_sc_hd__tapvpwrvgnd_1
XTAP_272 VGND VPWR sky130_fd_sc_hd__tapvpwrvgnd_1
XTAP_250 VGND VPWR sky130_fd_sc_hd__tapvpwrvgnd_1
XTAP_261 VGND VPWR sky130_fd_sc_hd__tapvpwrvgnd_1
XFILLER_0_44_191 VGND VGND VPWR VPWR sky130_fd_sc_hd__decap_4
XFILLER_0_36_136 VGND VGND VPWR VPWR sky130_fd_sc_hd__decap_4
XFILLER_0_19_39 VGND VGND VPWR VPWR sky130_fd_sc_hd__fill_1
XFILLER_0_35_27 VGND VGND VPWR VPWR sky130_fd_sc_hd__decap_8
XFILLER_0_51_15 VPWR VGND VPWR VGND sky130_ef_sc_hd__decap_12
X_0940_ _0332_ _0362_ _0344_ _0309_ VGND VGND VPWR VPWR _0368_ sky130_fd_sc_hd__or4b_4
XFILLER_0_27_103 VGND VGND VPWR VPWR sky130_fd_sc_hd__fill_1
XFILLER_0_42_139 VGND VGND VPWR VPWR sky130_fd_sc_hd__fill_1
X_0871_ _0314_ _0315_ VGND VGND VPWR VPWR _0316_ sky130_fd_sc_hd__or2_1
X_1285_ clknet_4_1_0_clk _0119_ VGND VGND VPWR VPWR u_sram.mem\[10\]\[1\] sky130_fd_sc_hd__dfxtp_1
XFILLER_0_5_81 VPWR VGND VPWR VGND sky130_ef_sc_hd__decap_12
XFILLER_0_49_261 VPWR VGND VPWR VGND sky130_ef_sc_hd__decap_12
XFILLER_0_24_139 VGND VGND VPWR VPWR sky130_fd_sc_hd__fill_1
XFILLER_0_46_15 VPWR VGND VPWR VGND sky130_ef_sc_hd__decap_12
X_1070_ _0422_ net132 _0451_ VGND VGND VPWR VPWR _0453_ sky130_fd_sc_hd__mux2_1
XFILLER_0_1_39 VPWR VGND VPWR VGND sky130_ef_sc_hd__decap_12
X_0854_ _0283_ _0291_ _0300_ _0301_ VGND VGND VPWR VPWR _0004_ sky130_fd_sc_hd__o31a_1
X_0923_ _0351_ net103 _0354_ VGND VGND VPWR VPWR _0356_ sky130_fd_sc_hd__mux2_1
X_0785_ u_sram.mem\[1\]\[1\] net11 _0166_ _0233_ VGND VGND VPWR VPWR _0234_ sky130_fd_sc_hd__a31o_1
XFILLER_0_23_150 VGND VGND VPWR VPWR sky130_fd_sc_hd__fill_2
Xhold19 u_sram.mem\[8\]\[1\] VGND VGND VPWR VPWR net35 sky130_fd_sc_hd__dlygate4sd3_1
X_1268_ clknet_4_12_0_clk _0102_ VGND VGND VPWR VPWR u_sram.mem\[19\]\[0\] sky130_fd_sc_hd__dfxtp_1
XFILLER_0_46_242 VGND VGND VPWR VPWR sky130_fd_sc_hd__decap_8
XFILLER_0_38_209 VPWR VGND VPWR VGND sky130_ef_sc_hd__decap_12
X_1199_ clknet_4_2_0_clk _0033_ VGND VGND VPWR VPWR u_sram.mem\[53\]\[1\] sky130_fd_sc_hd__dfxtp_1
XFILLER_0_46_253 VPWR VGND VPWR VGND sky130_ef_sc_hd__decap_12
XFILLER_0_14_194 VGND VGND VPWR VPWR sky130_fd_sc_hd__fill_2
X_1122_ _0485_ VGND VGND VPWR VPWR _0087_ sky130_fd_sc_hd__clkbuf_1
XFILLER_0_20_197 VGND VGND VPWR VPWR sky130_fd_sc_hd__decap_4
X_1053_ net54 _0434_ _0442_ VGND VGND VPWR VPWR _0443_ sky130_fd_sc_hd__mux2_1
XFILLER_0_28_220 VGND VGND VPWR VPWR sky130_fd_sc_hd__decap_6
X_0906_ _0307_ VGND VGND VPWR VPWR _0342_ sky130_fd_sc_hd__clkbuf_4
X_0837_ u_sram.mem\[2\]\[0\] net6 _0284_ VGND VGND VPWR VPWR _0285_ sky130_fd_sc_hd__a21o_1
XFILLER_0_51_3 VPWR VGND VPWR VGND sky130_ef_sc_hd__decap_12
X_0768_ u_sram.mem\[53\]\[1\] _0173_ net5 u_sram.mem\[56\]\[1\] VGND VGND VPWR VPWR
+ _0217_ sky130_fd_sc_hd__a22o_1
XFILLER_0_11_197 VGND VGND VPWR VPWR sky130_fd_sc_hd__fill_1
X_0699_ u_fsm.state\[0\] u_fsm.rvalid _0150_ u_fsm.state\[2\] VGND VGND VPWR VPWR
+ _0154_ sky130_fd_sc_hd__a211oi_1
XFILLER_0_19_220 VGND VGND VPWR VPWR sky130_fd_sc_hd__decap_4
XFILLER_0_43_27 VGND VGND VPWR VPWR sky130_fd_sc_hd__decap_4
XPHY_6 VGND VGND VPWR VPWR sky130_fd_sc_hd__decap_3
XFILLER_0_7_27 VPWR VGND VPWR VGND sky130_ef_sc_hd__decap_12
XFILLER_0_4_139 VGND VGND VPWR VPWR sky130_fd_sc_hd__fill_1
XFILLER_0_25_212 VPWR VGND VPWR VGND sky130_ef_sc_hd__decap_12
X_0622_ _0372_ _0519_ VGND VGND VPWR VPWR _0539_ sky130_fd_sc_hd__or2_1
X_1105_ _0353_ _0466_ VGND VGND VPWR VPWR _0475_ sky130_fd_sc_hd__or2_1
XFILLER_0_17_83 VPWR VGND VPWR VGND sky130_ef_sc_hd__decap_12
X_1036_ net154 _0361_ _0431_ VGND VGND VPWR VPWR _0432_ sky130_fd_sc_hd__mux2_1
XFILLER_0_33_93 VPWR VGND VPWR VGND sky130_ef_sc_hd__decap_12
Xhold116 u_sram.mem\[36\]\[0\] VGND VGND VPWR VPWR net132 sky130_fd_sc_hd__dlygate4sd3_1
Xhold105 u_sram.mem\[29\]\[1\] VGND VGND VPWR VPWR net121 sky130_fd_sc_hd__dlygate4sd3_1
Xhold138 u_sram.mem\[42\]\[1\] VGND VGND VPWR VPWR net154 sky130_fd_sc_hd__dlygate4sd3_1
Xhold127 u_sram.mem\[56\]\[0\] VGND VGND VPWR VPWR net143 sky130_fd_sc_hd__dlygate4sd3_1
XFILLER_0_0_153 VPWR VGND VPWR VGND sky130_ef_sc_hd__decap_12
XFILLER_0_0_197 VPWR VGND VPWR VGND sky130_ef_sc_hd__decap_12
X_0605_ _0492_ net96 _0527_ VGND VGND VPWR VPWR _0529_ sky130_fd_sc_hd__mux2_1
XFILLER_0_48_123 VGND VGND VPWR VPWR sky130_fd_sc_hd__fill_1
XFILLER_0_14_3 VGND VGND VPWR VPWR sky130_fd_sc_hd__decap_8
X_1019_ _0343_ net62 _0420_ VGND VGND VPWR VPWR _0421_ sky130_fd_sc_hd__mux2_1
XFILLER_0_8_253 VGND VGND VPWR VPWR sky130_fd_sc_hd__decap_8
XFILLER_0_24_29 VGND VGND VPWR VPWR sky130_fd_sc_hd__decap_8
XFILLER_0_49_15 VPWR VGND VPWR VGND sky130_ef_sc_hd__decap_12
XFILLER_0_14_62 VGND VGND VPWR VPWR sky130_fd_sc_hd__fill_2
XTAP_295 VGND VPWR sky130_fd_sc_hd__tapvpwrvgnd_1
XTAP_284 VGND VPWR sky130_fd_sc_hd__tapvpwrvgnd_1
XTAP_273 VGND VPWR sky130_fd_sc_hd__tapvpwrvgnd_1
XTAP_240 VGND VPWR sky130_fd_sc_hd__tapvpwrvgnd_1
XTAP_251 VGND VPWR sky130_fd_sc_hd__tapvpwrvgnd_1
XTAP_262 VGND VPWR sky130_fd_sc_hd__tapvpwrvgnd_1
XFILLER_0_3_3 VPWR VGND VPWR VGND sky130_ef_sc_hd__decap_12
XFILLER_0_19_29 VGND VGND VPWR VPWR sky130_fd_sc_hd__fill_1
XFILLER_0_51_27 VGND VGND VPWR VPWR sky130_fd_sc_hd__fill_1
X_0870_ u_fsm.state\[2\] u_fsm.state\[0\] _0150_ u_addr_gen.addr_valid VGND VGND VPWR
+ VPWR _0315_ sky130_fd_sc_hd__or4b_2
X_1284_ clknet_4_1_0_clk _0118_ VGND VGND VPWR VPWR u_sram.mem\[11\]\[0\] sky130_fd_sc_hd__dfxtp_1
X_0999_ _0310_ _0311_ u_addr_gen.addr\[3\] _0332_ VGND VGND VPWR VPWR _0407_ sky130_fd_sc_hd__or4_2
XFILLER_0_1_281 VPWR VGND VPWR VGND sky130_ef_sc_hd__decap_12
XFILLER_0_5_93 VPWR VGND VPWR VGND sky130_ef_sc_hd__decap_12
XFILLER_0_49_273 VGND VGND VPWR VPWR sky130_fd_sc_hd__decap_6
XFILLER_0_32_184 VPWR VGND VPWR VGND sky130_ef_sc_hd__decap_12
XFILLER_0_46_27 VGND VGND VPWR VPWR sky130_fd_sc_hd__fill_1
X_0922_ _0355_ VGND VGND VPWR VPWR _0017_ sky130_fd_sc_hd__clkbuf_1
X_0853_ net155 _0167_ net18 VGND VGND VPWR VPWR _0301_ sky130_fd_sc_hd__o21a_1
X_0784_ u_sram.mem\[16\]\[1\] net162 _0184_ VGND VGND VPWR VPWR _0233_ sky130_fd_sc_hd__and3_1
Xinput1 rst_n VGND VGND VPWR VPWR net1 sky130_fd_sc_hd__clkbuf_2
X_1198_ clknet_4_3_0_clk _0032_ VGND VGND VPWR VPWR u_sram.mem\[54\]\[0\] sky130_fd_sc_hd__dfxtp_1
X_1267_ clknet_4_12_0_clk _0101_ VGND VGND VPWR VPWR u_sram.mem\[19\]\[1\] sky130_fd_sc_hd__dfxtp_1
XFILLER_0_46_265 VPWR VGND VPWR VGND sky130_ef_sc_hd__decap_12
XFILLER_0_32_29 VGND VGND VPWR VPWR sky130_fd_sc_hd__decap_4
XFILLER_0_37_243 VPWR VGND VPWR VGND sky130_ef_sc_hd__decap_12
XFILLER_0_37_221 VGND VGND VPWR VPWR sky130_fd_sc_hd__decap_3
X_1121_ net58 _0434_ _0484_ VGND VGND VPWR VPWR _0485_ sky130_fd_sc_hd__mux2_1
X_1052_ _0337_ _0413_ VGND VGND VPWR VPWR _0442_ sky130_fd_sc_hd__nor2_1
XFILLER_0_43_279 VGND VGND VPWR VPWR sky130_fd_sc_hd__fill_1
X_0767_ u_sram.mem\[48\]\[1\] net10 _0210_ u_sram.mem\[59\]\[1\] _0215_ VGND VGND
+ VPWR VPWR _0216_ sky130_fd_sc_hd__a221o_1
X_0836_ u_sram.mem\[9\]\[0\] _0204_ _0210_ u_sram.mem\[11\]\[0\] VGND VGND VPWR VPWR
+ _0284_ sky130_fd_sc_hd__a22o_1
X_0905_ _0159_ _0003_ net20 VGND VGND VPWR VPWR _0014_ sky130_fd_sc_hd__o21bai_1
XFILLER_0_44_3 VPWR VGND VPWR VGND sky130_ef_sc_hd__decap_12
X_0698_ net34 _0148_ _0149_ u_fsm.state\[2\] _0003_ VGND VGND VPWR VPWR u_fsm.next_state\[2\]
+ sky130_fd_sc_hd__a221o_1
XFILLER_0_2_83 VGND VGND VPWR VPWR sky130_fd_sc_hd__fill_1
X_1319_ clknet_4_11_0_clk net18 net12 VGND VGND VPWR VPWR u_fsm.rvalid sky130_fd_sc_hd__dfrtp_1
XFILLER_0_34_202 VGND VGND VPWR VPWR sky130_fd_sc_hd__decap_8
XFILLER_0_6_181 VPWR VGND VPWR VGND sky130_ef_sc_hd__decap_12
XPHY_7 VGND VGND VPWR VPWR sky130_fd_sc_hd__decap_3
XFILLER_0_40_249 VGND VGND VPWR VPWR sky130_fd_sc_hd__decap_3
XFILLER_0_7_39 VGND VGND VPWR VPWR sky130_fd_sc_hd__fill_1
X_0621_ _0538_ VGND VGND VPWR VPWR _0120_ sky130_fd_sc_hd__clkbuf_1
XFILLER_0_48_305 VGND VGND VPWR VPWR sky130_fd_sc_hd__fill_1
X_1035_ _0368_ _0411_ VGND VGND VPWR VPWR _0431_ sky130_fd_sc_hd__nor2_1
XFILLER_0_17_95 VGND VGND VPWR VPWR sky130_fd_sc_hd__decap_6
X_1104_ _0474_ VGND VGND VPWR VPWR _0080_ sky130_fd_sc_hd__clkbuf_1
XFILLER_0_16_202 VGND VGND VPWR VPWR sky130_fd_sc_hd__fill_1
X_0819_ u_sram.mem\[8\]\[0\] _0166_ net5 VGND VGND VPWR VPWR _0267_ sky130_fd_sc_hd__and3_1
XFILLER_0_24_290 VPWR VGND VPWR VGND sky130_ef_sc_hd__decap_12
XFILLER_0_39_305 VGND VGND VPWR VPWR sky130_fd_sc_hd__fill_1
Xhold128 u_sram.mem\[62\]\[1\] VGND VGND VPWR VPWR net144 sky130_fd_sc_hd__dlygate4sd3_1
Xhold139 u_sram.mem\[0\]\[0\] VGND VGND VPWR VPWR net155 sky130_fd_sc_hd__dlygate4sd3_1
X_0604_ _0528_ VGND VGND VPWR VPWR _0113_ sky130_fd_sc_hd__clkbuf_1
XFILLER_0_13_205 VGND VGND VPWR VPWR sky130_fd_sc_hd__decap_3
Xhold117 u_sram.mem\[1\]\[1\] VGND VGND VPWR VPWR net133 sky130_fd_sc_hd__dlygate4sd3_1
Xhold106 u_sram.mem\[25\]\[1\] VGND VGND VPWR VPWR net122 sky130_fd_sc_hd__dlygate4sd3_1
XFILLER_0_0_165 VGND VGND VPWR VPWR sky130_fd_sc_hd__decap_3
XFILLER_0_44_93 VGND VGND VPWR VPWR sky130_fd_sc_hd__decap_4
X_1018_ _0353_ _0411_ VGND VGND VPWR VPWR _0420_ sky130_fd_sc_hd__or2_1
XFILLER_0_40_29 VGND VGND VPWR VPWR sky130_fd_sc_hd__fill_2
XFILLER_0_49_27 VPWR VGND VPWR VGND sky130_ef_sc_hd__decap_12
XFILLER_0_4_29 VPWR VGND VPWR VGND sky130_ef_sc_hd__decap_12
XFILLER_0_14_85 VGND VGND VPWR VPWR sky130_fd_sc_hd__fill_1
XTAP_230 VGND VPWR sky130_fd_sc_hd__tapvpwrvgnd_1
XTAP_241 VGND VPWR sky130_fd_sc_hd__tapvpwrvgnd_1
XTAP_296 VGND VPWR sky130_fd_sc_hd__tapvpwrvgnd_1
XTAP_285 VGND VPWR sky130_fd_sc_hd__tapvpwrvgnd_1
XTAP_274 VGND VPWR sky130_fd_sc_hd__tapvpwrvgnd_1
XTAP_263 VGND VPWR sky130_fd_sc_hd__tapvpwrvgnd_1
XTAP_252 VGND VPWR sky130_fd_sc_hd__tapvpwrvgnd_1
Xfanout12 net14 VGND VGND VPWR VPWR net12 sky130_fd_sc_hd__clkbuf_4
XFILLER_0_32_300 VGND VGND VPWR VPWR sky130_fd_sc_hd__fill_2
XFILLER_0_50_141 VPWR VGND VPWR VGND sky130_ef_sc_hd__decap_12
XFILLER_0_2_227 VPWR VGND VPWR VGND sky130_ef_sc_hd__decap_12
X_1283_ clknet_4_0_0_clk _0117_ VGND VGND VPWR VPWR u_sram.mem\[11\]\[1\] sky130_fd_sc_hd__dfxtp_1
XFILLER_0_41_185 VGND VGND VPWR VPWR sky130_fd_sc_hd__fill_1
X_0998_ _0406_ VGND VGND VPWR VPWR _0042_ sky130_fd_sc_hd__clkbuf_1
XFILLER_0_26_193 VGND VGND VPWR VPWR sky130_fd_sc_hd__decap_3
XFILLER_0_1_293 VPWR VGND VPWR VGND sky130_ef_sc_hd__decap_12
X_0921_ _0343_ net42 _0354_ VGND VGND VPWR VPWR _0355_ sky130_fd_sc_hd__mux2_1
X_0852_ _0293_ _0299_ _0223_ VGND VGND VPWR VPWR _0300_ sky130_fd_sc_hd__o21a_1
X_0783_ _0185_ _0227_ _0229_ _0231_ VGND VGND VPWR VPWR _0232_ sky130_fd_sc_hd__a211o_1
Xinput2 start VGND VGND VPWR VPWR net2 sky130_fd_sc_hd__buf_1
X_1197_ clknet_4_2_0_clk _0031_ VGND VGND VPWR VPWR u_sram.mem\[54\]\[1\] sky130_fd_sc_hd__dfxtp_1
X_1266_ clknet_4_4_0_clk _0100_ VGND VGND VPWR VPWR u_sram.mem\[20\]\[0\] sky130_fd_sc_hd__dfxtp_1
XFILLER_0_46_277 VPWR VGND VPWR VGND sky130_ef_sc_hd__decap_12
XFILLER_0_37_255 VPWR VGND VPWR VGND sky130_ef_sc_hd__decap_12
X_1051_ _0441_ VGND VGND VPWR VPWR _0060_ sky130_fd_sc_hd__clkbuf_1
X_1120_ _0368_ _0466_ VGND VGND VPWR VPWR _0484_ sky130_fd_sc_hd__nor2_1
XFILLER_0_43_225 VPWR VGND VPWR VGND sky130_ef_sc_hd__decap_12
X_0904_ _0330_ _0341_ _0338_ u_addr_gen.addr\[5\] VGND VGND VPWR VPWR _0013_ sky130_fd_sc_hd__a2bb2o_1
XFILLER_0_28_277 VGND VGND VPWR VPWR sky130_fd_sc_hd__decap_3
X_0766_ u_sram.mem\[50\]\[1\] net7 _0203_ u_sram.mem\[62\]\[1\] VGND VGND VPWR VPWR
+ _0215_ sky130_fd_sc_hd__a22o_1
XFILLER_0_11_111 VGND VGND VPWR VPWR sky130_fd_sc_hd__fill_1
XFILLER_0_11_144 VGND VGND VPWR VPWR sky130_fd_sc_hd__fill_2
X_0697_ _0153_ VGND VGND VPWR VPWR _0003_ sky130_fd_sc_hd__clkbuf_2
X_0835_ _0169_ _0250_ _0261_ _0274_ _0282_ VGND VGND VPWR VPWR _0283_ sky130_fd_sc_hd__a2111o_1
XFILLER_0_37_3 VPWR VGND VPWR VGND sky130_ef_sc_hd__decap_12
X_1318_ clknet_4_10_0_clk _0143_ net12 VGND VGND VPWR VPWR u_pattern_gen.state_r\[1\]
+ sky130_fd_sc_hd__dfrtp_1
X_1249_ clknet_4_5_0_clk _0083_ VGND VGND VPWR VPWR u_sram.mem\[28\]\[1\] sky130_fd_sc_hd__dfxtp_1
XFILLER_0_6_193 VGND VGND VPWR VPWR sky130_fd_sc_hd__decap_3
XPHY_8 VGND VGND VPWR VPWR sky130_fd_sc_hd__decap_3
X_0620_ _0492_ net157 _0536_ VGND VGND VPWR VPWR _0538_ sky130_fd_sc_hd__mux2_1
XFILLER_0_33_51 VGND VGND VPWR VPWR sky130_fd_sc_hd__decap_4
X_1034_ _0430_ VGND VGND VPWR VPWR _0054_ sky130_fd_sc_hd__clkbuf_1
X_1103_ _0422_ net37 _0472_ VGND VGND VPWR VPWR _0474_ sky130_fd_sc_hd__mux2_1
XFILLER_0_16_247 VGND VGND VPWR VPWR sky130_fd_sc_hd__decap_4
X_0749_ u_sram.mem\[18\]\[1\] net6 _0194_ u_sram.mem\[23\]\[1\] VGND VGND VPWR VPWR
+ _0198_ sky130_fd_sc_hd__a22o_1
X_0818_ _0262_ _0263_ _0264_ _0265_ VGND VGND VPWR VPWR _0266_ sky130_fd_sc_hd__or4_1
Xhold107 u_sram.mem\[27\]\[1\] VGND VGND VPWR VPWR net123 sky130_fd_sc_hd__dlygate4sd3_1
Xhold129 u_sram.mem\[50\]\[0\] VGND VGND VPWR VPWR net145 sky130_fd_sc_hd__dlygate4sd3_1
X_0603_ _0503_ net140 _0527_ VGND VGND VPWR VPWR _0528_ sky130_fd_sc_hd__mux2_1
Xhold118 u_sram.mem\[14\]\[1\] VGND VGND VPWR VPWR net134 sky130_fd_sc_hd__dlygate4sd3_1
XFILLER_0_44_83 VGND VGND VPWR VPWR sky130_fd_sc_hd__fill_1
X_1017_ _0419_ VGND VGND VPWR VPWR _0048_ sky130_fd_sc_hd__clkbuf_1
XFILLER_0_8_72 VGND VGND VPWR VPWR sky130_fd_sc_hd__fill_1
XFILLER_0_12_250 VGND VGND VPWR VPWR sky130_fd_sc_hd__fill_2
XFILLER_0_50_301 VGND VGND VPWR VPWR sky130_fd_sc_hd__decap_4
XFILLER_0_39_169 VGND VGND VPWR VPWR sky130_fd_sc_hd__fill_1
XFILLER_0_39_136 VGND VGND VPWR VPWR sky130_fd_sc_hd__decap_3
XFILLER_0_49_39 VPWR VGND VPWR VGND sky130_ef_sc_hd__decap_12
XTAP_275 VGND VPWR sky130_fd_sc_hd__tapvpwrvgnd_1
XTAP_264 VGND VPWR sky130_fd_sc_hd__tapvpwrvgnd_1
XTAP_220 VGND VPWR sky130_fd_sc_hd__tapvpwrvgnd_1
XTAP_231 VGND VPWR sky130_fd_sc_hd__tapvpwrvgnd_1
XTAP_242 VGND VPWR sky130_fd_sc_hd__tapvpwrvgnd_1
XTAP_253 VGND VPWR sky130_fd_sc_hd__tapvpwrvgnd_1
XTAP_297 VGND VPWR sky130_fd_sc_hd__tapvpwrvgnd_1
XTAP_286 VGND VPWR sky130_fd_sc_hd__tapvpwrvgnd_1
XFILLER_0_51_109 VGND VGND VPWR VPWR sky130_fd_sc_hd__decap_3
Xfanout13 net14 VGND VGND VPWR VPWR net13 sky130_fd_sc_hd__clkbuf_2
XFILLER_0_29_191 VGND VGND VPWR VPWR sky130_fd_sc_hd__fill_2
XFILLER_0_44_161 VGND VGND VPWR VPWR sky130_fd_sc_hd__decap_3
XFILLER_0_51_29 VPWR VGND VPWR VGND sky130_ef_sc_hd__decap_12
XFILLER_0_35_183 VGND VGND VPWR VPWR sky130_fd_sc_hd__fill_1
XFILLER_0_23_301 VGND VGND VPWR VPWR sky130_fd_sc_hd__decap_4
XFILLER_0_50_197 VPWR VGND VPWR VGND sky130_ef_sc_hd__decap_12
XFILLER_0_50_153 VPWR VGND VPWR VGND sky130_ef_sc_hd__decap_12
XFILLER_0_2_239 VPWR VGND VPWR VGND sky130_ef_sc_hd__decap_12
X_1282_ clknet_4_0_0_clk _0116_ VGND VGND VPWR VPWR u_sram.mem\[12\]\[0\] sky130_fd_sc_hd__dfxtp_1
XFILLER_0_41_84 VGND VGND VPWR VPWR sky130_fd_sc_hd__decap_4
XFILLER_0_18_139 VGND VGND VPWR VPWR sky130_fd_sc_hd__fill_1
XFILLER_0_1_261 VPWR VGND VPWR VGND sky130_ef_sc_hd__decap_12
X_0997_ _0351_ net129 _0404_ VGND VGND VPWR VPWR _0406_ sky130_fd_sc_hd__mux2_1
XFILLER_0_26_150 VGND VGND VPWR VPWR sky130_fd_sc_hd__decap_6
XFILLER_0_5_51 VGND VGND VPWR VPWR sky130_fd_sc_hd__decap_4
XFILLER_0_17_183 VPWR VGND VPWR VGND sky130_ef_sc_hd__decap_12
XFILLER_0_32_197 VGND VGND VPWR VPWR sky130_fd_sc_hd__decap_3
XFILLER_0_46_29 VPWR VGND VPWR VGND sky130_ef_sc_hd__decap_12
X_0920_ _0314_ _0353_ VGND VGND VPWR VPWR _0354_ sky130_fd_sc_hd__or2_1
X_0851_ _0295_ _0297_ _0298_ VGND VGND VPWR VPWR _0299_ sky130_fd_sc_hd__or3_1
XFILLER_0_11_65 VGND VGND VPWR VPWR sky130_fd_sc_hd__fill_1
XFILLER_0_11_87 VGND VGND VPWR VPWR sky130_fd_sc_hd__fill_1
X_0782_ u_sram.mem\[57\]\[1\] _0204_ _0223_ _0230_ _0166_ VGND VGND VPWR VPWR _0231_
+ sky130_fd_sc_hd__a32o_1
XFILLER_0_23_197 VGND VGND VPWR VPWR sky130_fd_sc_hd__decap_4
X_1265_ clknet_4_4_0_clk _0099_ VGND VGND VPWR VPWR u_sram.mem\[20\]\[1\] sky130_fd_sc_hd__dfxtp_1
X_1196_ clknet_4_8_0_clk _0030_ VGND VGND VPWR VPWR u_sram.mem\[55\]\[0\] sky130_fd_sc_hd__dfxtp_1
XFILLER_0_46_289 VPWR VGND VPWR VGND sky130_ef_sc_hd__decap_12
XFILLER_0_14_120 VGND VGND VPWR VPWR sky130_fd_sc_hd__decap_4
XFILLER_0_14_197 VGND VGND VPWR VPWR sky130_fd_sc_hd__decap_3
XFILLER_0_37_267 VPWR VGND VPWR VGND sky130_ef_sc_hd__decap_12
X_1050_ _0422_ net57 _0439_ VGND VGND VPWR VPWR _0441_ sky130_fd_sc_hd__mux2_1
XFILLER_0_43_237 VPWR VGND VPWR VGND sky130_ef_sc_hd__decap_12
X_0903_ u_addr_gen.addr\[5\] _0324_ VGND VGND VPWR VPWR _0341_ sky130_fd_sc_hd__or2_1
X_0834_ _0185_ _0277_ _0279_ _0281_ VGND VGND VPWR VPWR _0282_ sky130_fd_sc_hd__a211o_1
XFILLER_0_51_281 VPWR VGND VPWR VGND sky130_ef_sc_hd__decap_12
X_0765_ _0169_ _0182_ _0197_ _0202_ _0213_ VGND VGND VPWR VPWR _0214_ sky130_fd_sc_hd__a2111o_1
XFILLER_0_11_167 VGND VGND VPWR VPWR sky130_fd_sc_hd__fill_1
X_0696_ u_fsm.addr_done_seen _0151_ _0152_ VGND VGND VPWR VPWR _0153_ sky130_fd_sc_hd__a21o_1
X_1248_ clknet_4_5_0_clk _0082_ VGND VGND VPWR VPWR u_sram.mem\[29\]\[0\] sky130_fd_sc_hd__dfxtp_1
XFILLER_0_2_41 VPWR VGND VPWR VGND sky130_ef_sc_hd__decap_12
X_1317_ clknet_4_10_0_clk _0142_ net12 VGND VGND VPWR VPWR u_pattern_gen.state_r\[0\]
+ sky130_fd_sc_hd__dfrtp_4
XFILLER_0_2_85 VPWR VGND VPWR VGND sky130_ef_sc_hd__decap_12
X_1179_ clknet_4_14_0_clk _0581_ net13 VGND VGND VPWR VPWR u_addr_gen.done sky130_fd_sc_hd__dfrtp_1
XFILLER_0_34_248 VGND VGND VPWR VPWR sky130_fd_sc_hd__fill_1
XFILLER_0_6_161 VGND VGND VPWR VPWR sky130_fd_sc_hd__decap_3
XFILLER_0_19_278 VGND VGND VPWR VPWR sky130_fd_sc_hd__fill_2
XPHY_9 VGND VGND VPWR VPWR sky130_fd_sc_hd__decap_3
Xmax_cap10 net162 VGND VGND VPWR VPWR net10 sky130_fd_sc_hd__clkbuf_2
XFILLER_0_4_109 VGND VGND VPWR VPWR sky130_fd_sc_hd__decap_4
XFILLER_0_33_281 VPWR VGND VPWR VGND sky130_ef_sc_hd__decap_12
XFILLER_0_25_259 VGND VGND VPWR VPWR sky130_fd_sc_hd__fill_1
X_1102_ _0473_ VGND VGND VPWR VPWR _0079_ sky130_fd_sc_hd__clkbuf_1
X_1033_ net32 _0366_ _0428_ VGND VGND VPWR VPWR _0430_ sky130_fd_sc_hd__mux2_1
X_0817_ u_sram.mem\[43\]\[0\] _0168_ _0210_ VGND VGND VPWR VPWR _0265_ sky130_fd_sc_hd__and3_1
XFILLER_0_3_186 VGND VGND VPWR VPWR sky130_fd_sc_hd__decap_3
X_0679_ u_comparator.pass_fail VGND VGND VPWR VPWR _0572_ sky130_fd_sc_hd__inv_2
X_0748_ _0188_ _0191_ _0193_ _0196_ VGND VGND VPWR VPWR _0197_ sky130_fd_sc_hd__or4_1
XFILLER_0_15_281 VGND VGND VPWR VPWR sky130_fd_sc_hd__fill_1
Xhold108 u_sram.mem\[56\]\[1\] VGND VGND VPWR VPWR net124 sky130_fd_sc_hd__dlygate4sd3_1
Xhold119 u_sram.mem\[26\]\[0\] VGND VGND VPWR VPWR net135 sky130_fd_sc_hd__dlygate4sd3_1
X_0602_ _0353_ _0519_ VGND VGND VPWR VPWR _0527_ sky130_fd_sc_hd__or2_1
X_1016_ _0351_ net156 _0417_ VGND VGND VPWR VPWR _0419_ sky130_fd_sc_hd__mux2_1
XFILLER_0_45_129 VGND VGND VPWR VPWR sky130_fd_sc_hd__decap_3
XFILLER_0_14_21 VGND VGND VPWR VPWR sky130_fd_sc_hd__fill_1
XFILLER_0_39_84 VGND VGND VPWR VPWR sky130_fd_sc_hd__decap_4
XTAP_298 VGND VPWR sky130_fd_sc_hd__tapvpwrvgnd_1
XTAP_287 VGND VPWR sky130_fd_sc_hd__tapvpwrvgnd_1
XTAP_276 VGND VPWR sky130_fd_sc_hd__tapvpwrvgnd_1
XTAP_265 VGND VPWR sky130_fd_sc_hd__tapvpwrvgnd_1
XTAP_210 VGND VPWR sky130_fd_sc_hd__tapvpwrvgnd_1
XTAP_221 VGND VPWR sky130_fd_sc_hd__tapvpwrvgnd_1
XTAP_232 VGND VPWR sky130_fd_sc_hd__tapvpwrvgnd_1
XTAP_243 VGND VPWR sky130_fd_sc_hd__tapvpwrvgnd_1
XTAP_254 VGND VPWR sky130_fd_sc_hd__tapvpwrvgnd_1
XFILLER_0_12_3 VPWR VGND VPWR VGND sky130_ef_sc_hd__decap_12
Xfanout14 net1 VGND VGND VPWR VPWR net14 sky130_fd_sc_hd__clkbuf_4
XFILLER_0_44_195 VGND VGND VPWR VPWR sky130_fd_sc_hd__fill_1
XFILLER_0_50_165 VPWR VGND VPWR VGND sky130_ef_sc_hd__decap_12
XFILLER_0_50_132 VGND VGND VPWR VPWR sky130_fd_sc_hd__decap_8
XFILLER_0_35_173 VGND VGND VPWR VPWR sky130_fd_sc_hd__fill_1
XFILLER_0_35_140 VGND VGND VPWR VPWR sky130_fd_sc_hd__decap_4
X_1281_ clknet_4_0_0_clk _0115_ VGND VGND VPWR VPWR u_sram.mem\[12\]\[1\] sky130_fd_sc_hd__dfxtp_1
XFILLER_0_41_74 VGND VGND VPWR VPWR sky130_fd_sc_hd__fill_2
XFILLER_0_41_52 VGND VGND VPWR VPWR sky130_fd_sc_hd__decap_4
X_0996_ _0405_ VGND VGND VPWR VPWR _0041_ sky130_fd_sc_hd__clkbuf_1
XFILLER_0_14_302 VGND VGND VPWR VPWR sky130_fd_sc_hd__decap_4
XFILLER_0_41_165 VGND VGND VPWR VPWR sky130_fd_sc_hd__decap_3
XFILLER_0_41_132 VGND VGND VPWR VPWR sky130_fd_sc_hd__fill_2
XFILLER_0_41_110 VGND VGND VPWR VPWR sky130_fd_sc_hd__fill_2
XFILLER_0_1_273 VGND VGND VPWR VPWR sky130_fd_sc_hd__decap_6
XFILLER_0_17_195 VGND VGND VPWR VPWR sky130_fd_sc_hd__decap_8
XFILLER_0_1_3 VPWR VGND VPWR VGND sky130_ef_sc_hd__decap_12
X_0850_ u_sram.mem\[51\]\[0\] _0179_ _0210_ u_sram.mem\[59\]\[0\] VGND VGND VPWR VPWR
+ _0298_ sky130_fd_sc_hd__a22o_1
XFILLER_0_11_55 VGND VGND VPWR VPWR sky130_fd_sc_hd__fill_1
XFILLER_0_11_305 VGND VGND VPWR VPWR sky130_fd_sc_hd__fill_1
X_0781_ u_sram.mem\[5\]\[1\] _0173_ _0175_ u_sram.mem\[6\]\[1\] VGND VGND VPWR VPWR
+ _0230_ sky130_fd_sc_hd__a22o_1
X_1264_ clknet_4_4_0_clk _0098_ VGND VGND VPWR VPWR u_sram.mem\[21\]\[0\] sky130_fd_sc_hd__dfxtp_1
X_1195_ clknet_4_8_0_clk _0029_ VGND VGND VPWR VPWR u_sram.mem\[55\]\[1\] sky130_fd_sc_hd__dfxtp_1
XFILLER_0_14_165 VGND VGND VPWR VPWR sky130_fd_sc_hd__fill_2
X_0979_ _0351_ net102 _0392_ VGND VGND VPWR VPWR _0394_ sky130_fd_sc_hd__mux2_1
XFILLER_0_37_279 VGND VGND VPWR VPWR sky130_fd_sc_hd__fill_1
XFILLER_0_43_249 VPWR VGND VPWR VGND sky130_ef_sc_hd__decap_12
X_0902_ _0340_ VGND VGND VPWR VPWR _0012_ sky130_fd_sc_hd__clkbuf_1
XFILLER_0_7_107 VGND VGND VPWR VPWR sky130_fd_sc_hd__decap_4
X_0833_ u_sram.mem\[57\]\[0\] _0204_ _0223_ _0280_ _0166_ VGND VGND VPWR VPWR _0281_
+ sky130_fd_sc_hd__a32o_1
XFILLER_0_22_98 VGND VGND VPWR VPWR sky130_fd_sc_hd__fill_2
XFILLER_0_51_293 VPWR VGND VPWR VGND sky130_ef_sc_hd__decap_12
XFILLER_0_11_113 VGND VGND VPWR VPWR sky130_fd_sc_hd__decap_8
X_0695_ net2 u_fsm.state\[0\] u_fsm.state\[1\] u_fsm.state\[2\] VGND VGND VPWR VPWR
+ _0152_ sky130_fd_sc_hd__and4bb_1
X_0764_ _0206_ _0212_ _0166_ VGND VGND VPWR VPWR _0213_ sky130_fd_sc_hd__o21a_1
XFILLER_0_47_51 VGND VGND VPWR VPWR sky130_fd_sc_hd__decap_4
X_1247_ clknet_4_5_0_clk _0081_ VGND VGND VPWR VPWR u_sram.mem\[29\]\[1\] sky130_fd_sc_hd__dfxtp_1
X_1178_ clknet_4_15_0_clk _0013_ net16 VGND VGND VPWR VPWR u_addr_gen.addr\[5\] sky130_fd_sc_hd__dfrtp_4
XFILLER_0_2_53 VPWR VGND VPWR VGND sky130_ef_sc_hd__decap_12
X_1316_ clknet_4_10_0_clk _0004_ net14 VGND VGND VPWR VPWR u_comparator.read_data\[0\]
+ sky130_fd_sc_hd__dfrtp_1
XFILLER_0_2_97 VPWR VGND VPWR VGND sky130_ef_sc_hd__decap_12
XFILLER_0_19_246 VPWR VGND VPWR VGND sky130_ef_sc_hd__decap_12
XFILLER_0_10_190 VGND VGND VPWR VPWR sky130_fd_sc_hd__fill_1
Xmax_cap11 net163 VGND VGND VPWR VPWR net11 sky130_fd_sc_hd__clkbuf_2
XFILLER_0_33_293 VPWR VGND VPWR VGND sky130_ef_sc_hd__decap_12
XFILLER_0_33_271 VGND VGND VPWR VPWR sky130_fd_sc_hd__decap_8
XFILLER_0_0_305 VGND VGND VPWR VPWR sky130_fd_sc_hd__fill_1
X_1032_ _0429_ VGND VGND VPWR VPWR _0053_ sky130_fd_sc_hd__clkbuf_1
X_1101_ _0424_ net78 _0472_ VGND VGND VPWR VPWR _0473_ sky130_fd_sc_hd__mux2_1
X_0747_ u_sram.mem\[39\]\[1\] _0169_ _0194_ _0195_ VGND VGND VPWR VPWR _0196_ sky130_fd_sc_hd__a31o_1
X_0816_ u_sram.mem\[30\]\[0\] _0203_ _0183_ VGND VGND VPWR VPWR _0264_ sky130_fd_sc_hd__and3_1
XFILLER_0_42_3 VPWR VGND VPWR VGND sky130_ef_sc_hd__decap_12
X_0678_ net31 _0000_ _0571_ _0303_ VGND VGND VPWR VPWR _0144_ sky130_fd_sc_hd__a22o_1
Xhold109 u_sram.mem\[60\]\[0\] VGND VGND VPWR VPWR net125 sky130_fd_sc_hd__dlygate4sd3_1
X_0601_ _0526_ VGND VGND VPWR VPWR _0112_ sky130_fd_sc_hd__clkbuf_1
XFILLER_0_0_113 VPWR VGND VPWR VGND sky130_ef_sc_hd__decap_12
XFILLER_0_21_285 VGND VGND VPWR VPWR sky130_fd_sc_hd__decap_6
XFILLER_0_48_105 VGND VGND VPWR VPWR sky130_fd_sc_hd__fill_2
XFILLER_0_44_41 VGND VGND VPWR VPWR sky130_fd_sc_hd__decap_8
X_1015_ _0418_ VGND VGND VPWR VPWR _0047_ sky130_fd_sc_hd__clkbuf_1
XFILLER_0_8_41 VGND VGND VPWR VPWR sky130_fd_sc_hd__decap_3
XFILLER_0_14_11 VGND VGND VPWR VPWR sky130_fd_sc_hd__decap_3
XFILLER_0_39_41 VGND VGND VPWR VPWR sky130_fd_sc_hd__fill_2
XTAP_299 VGND VPWR sky130_fd_sc_hd__tapvpwrvgnd_1
XTAP_288 VGND VPWR sky130_fd_sc_hd__tapvpwrvgnd_1
XTAP_277 VGND VPWR sky130_fd_sc_hd__tapvpwrvgnd_1
XTAP_266 VGND VPWR sky130_fd_sc_hd__tapvpwrvgnd_1
XTAP_200 VGND VPWR sky130_fd_sc_hd__tapvpwrvgnd_1
XTAP_211 VGND VPWR sky130_fd_sc_hd__tapvpwrvgnd_1
XTAP_222 VGND VPWR sky130_fd_sc_hd__tapvpwrvgnd_1
XTAP_233 VGND VPWR sky130_fd_sc_hd__tapvpwrvgnd_1
XTAP_244 VGND VPWR sky130_fd_sc_hd__tapvpwrvgnd_1
XTAP_255 VGND VPWR sky130_fd_sc_hd__tapvpwrvgnd_1
Xfanout15 net1 VGND VGND VPWR VPWR net15 sky130_fd_sc_hd__buf_4
XFILLER_0_44_141 VGND VGND VPWR VPWR sky130_fd_sc_hd__decap_8
XFILLER_0_50_177 VGND VGND VPWR VPWR sky130_fd_sc_hd__fill_1
XFILLER_0_50_111 VPWR VGND VPWR VGND sky130_ef_sc_hd__decap_12
X_1280_ clknet_4_0_0_clk _0114_ VGND VGND VPWR VPWR u_sram.mem\[13\]\[0\] sky130_fd_sc_hd__dfxtp_1
XFILLER_0_25_87 VGND VGND VPWR VPWR sky130_fd_sc_hd__fill_1
X_0995_ _0343_ net100 _0404_ VGND VGND VPWR VPWR _0405_ sky130_fd_sc_hd__mux2_1
XFILLER_0_17_141 VGND VGND VPWR VPWR sky130_fd_sc_hd__decap_4
X_0780_ u_sram.mem\[58\]\[1\] _0199_ _0223_ _0228_ VGND VGND VPWR VPWR _0229_ sky130_fd_sc_hd__a31o_1
X_1194_ clknet_4_2_0_clk _0028_ VGND VGND VPWR VPWR u_sram.mem\[56\]\[0\] sky130_fd_sc_hd__dfxtp_1
X_1263_ clknet_4_4_0_clk _0097_ VGND VGND VPWR VPWR u_sram.mem\[21\]\[1\] sky130_fd_sc_hd__dfxtp_1
X_0978_ _0393_ VGND VGND VPWR VPWR _0035_ sky130_fd_sc_hd__clkbuf_1
XFILLER_0_22_11 VGND VGND VPWR VPWR sky130_fd_sc_hd__fill_1
X_0901_ _0338_ _0339_ VGND VGND VPWR VPWR _0340_ sky130_fd_sc_hd__and2_1
X_0763_ _0208_ _0209_ _0211_ VGND VGND VPWR VPWR _0212_ sky130_fd_sc_hd__or3_1
X_0832_ u_sram.mem\[5\]\[0\] _0173_ _0175_ u_sram.mem\[6\]\[0\] VGND VGND VPWR VPWR
+ _0280_ sky130_fd_sc_hd__a22o_1
X_1315_ clknet_4_11_0_clk _0005_ net14 VGND VGND VPWR VPWR u_comparator.read_data\[1\]
+ sky130_fd_sc_hd__dfrtp_1
X_0694_ u_fsm.state\[2\] u_fsm.state\[0\] _0150_ VGND VGND VPWR VPWR _0151_ sky130_fd_sc_hd__and3_1
X_1177_ clknet_4_15_0_clk _0012_ net16 VGND VGND VPWR VPWR u_addr_gen.addr\[4\] sky130_fd_sc_hd__dfrtp_4
XFILLER_0_2_65 VPWR VGND VPWR VGND sky130_ef_sc_hd__decap_12
X_1246_ clknet_4_15_0_clk _0080_ VGND VGND VPWR VPWR u_sram.mem\[30\]\[0\] sky130_fd_sc_hd__dfxtp_1
XFILLER_0_19_225 VGND VGND VPWR VPWR sky130_fd_sc_hd__fill_2
XFILLER_0_19_258 VPWR VGND VPWR VGND sky130_ef_sc_hd__decap_12
Xclkbuf_4_9_0_clk clknet_0_clk VGND VGND VPWR VPWR clknet_4_9_0_clk sky130_fd_sc_hd__clkbuf_8
X_1100_ _0347_ _0466_ VGND VGND VPWR VPWR _0472_ sky130_fd_sc_hd__or2_1
XFILLER_0_17_33 VPWR VGND VPWR VGND sky130_ef_sc_hd__decap_12
X_1031_ net66 _0361_ _0428_ VGND VGND VPWR VPWR _0429_ sky130_fd_sc_hd__mux2_1
XFILLER_0_16_206 VGND VGND VPWR VPWR sky130_fd_sc_hd__fill_1
XFILLER_0_3_111 VGND VGND VPWR VPWR sky130_fd_sc_hd__fill_1
XFILLER_0_24_250 VGND VGND VPWR VPWR sky130_fd_sc_hd__fill_2
X_0815_ u_sram.mem\[16\]\[0\] net10 _0183_ VGND VGND VPWR VPWR _0263_ sky130_fd_sc_hd__and3_1
X_0746_ u_sram.mem\[20\]\[1\] net8 _0184_ VGND VGND VPWR VPWR _0195_ sky130_fd_sc_hd__and3_1
XFILLER_0_35_3 VPWR VGND VPWR VGND sky130_ef_sc_hd__decap_12
X_0677_ u_addr_gen.state\[0\] _0305_ _0302_ VGND VGND VPWR VPWR _0571_ sky130_fd_sc_hd__o21ai_1
X_1229_ clknet_4_7_0_clk _0063_ VGND VGND VPWR VPWR u_sram.mem\[38\]\[1\] sky130_fd_sc_hd__dfxtp_1
XFILLER_0_0_125 VPWR VGND VPWR VGND sky130_ef_sc_hd__decap_12
X_0600_ _0492_ net142 _0524_ VGND VGND VPWR VPWR _0526_ sky130_fd_sc_hd__mux2_1
XFILLER_0_0_169 VPWR VGND VPWR VGND sky130_ef_sc_hd__decap_12
X_1014_ _0343_ net127 _0417_ VGND VGND VPWR VPWR _0418_ sky130_fd_sc_hd__mux2_1
XFILLER_0_44_301 VGND VGND VPWR VPWR sky130_fd_sc_hd__decap_4
X_0729_ u_sram.addr_r\[1\] u_sram.addr_r\[3\] u_sram.addr_r\[2\] u_sram.addr_r\[0\]
+ VGND VGND VPWR VPWR _0178_ sky130_fd_sc_hd__nor4b_2
XFILLER_0_12_253 VPWR VGND VPWR VGND sky130_ef_sc_hd__decap_12
XFILLER_0_39_106 VGND VGND VPWR VPWR sky130_fd_sc_hd__decap_6
XTAP_201 VGND VPWR sky130_fd_sc_hd__tapvpwrvgnd_1
XTAP_212 VGND VPWR sky130_fd_sc_hd__tapvpwrvgnd_1
XTAP_223 VGND VPWR sky130_fd_sc_hd__tapvpwrvgnd_1
XTAP_289 VGND VPWR sky130_fd_sc_hd__tapvpwrvgnd_1
XTAP_278 VGND VPWR sky130_fd_sc_hd__tapvpwrvgnd_1
XTAP_267 VGND VPWR sky130_fd_sc_hd__tapvpwrvgnd_1
XTAP_234 VGND VPWR sky130_fd_sc_hd__tapvpwrvgnd_1
XTAP_245 VGND VPWR sky130_fd_sc_hd__tapvpwrvgnd_1
XTAP_256 VGND VPWR sky130_fd_sc_hd__tapvpwrvgnd_1
Xfanout16 net1 VGND VGND VPWR VPWR net16 sky130_fd_sc_hd__clkbuf_2
XFILLER_0_44_197 VPWR VGND VPWR VGND sky130_ef_sc_hd__decap_12
XFILLER_0_44_153 VGND VGND VPWR VPWR sky130_fd_sc_hd__decap_8
XFILLER_0_29_183 VGND VGND VPWR VPWR sky130_fd_sc_hd__decap_3
XFILLER_0_27_109 VGND VGND VPWR VPWR sky130_fd_sc_hd__decap_3
XFILLER_0_50_123 VGND VGND VPWR VPWR sky130_fd_sc_hd__fill_1
XFILLER_0_25_55 VGND VGND VPWR VPWR sky130_fd_sc_hd__fill_1
X_0994_ _0317_ _0403_ VGND VGND VPWR VPWR _0404_ sky130_fd_sc_hd__or2_1
XFILLER_0_49_223 VGND VGND VPWR VPWR sky130_fd_sc_hd__fill_1
XFILLER_0_17_175 VGND VGND VPWR VPWR sky130_fd_sc_hd__decap_3
XFILLER_0_11_35 VGND VGND VPWR VPWR sky130_fd_sc_hd__fill_2
XFILLER_0_11_57 VGND VGND VPWR VPWR sky130_fd_sc_hd__fill_1
XFILLER_0_36_76 VGND VGND VPWR VPWR sky130_fd_sc_hd__fill_1
X_1193_ clknet_4_2_0_clk _0027_ VGND VGND VPWR VPWR u_sram.mem\[56\]\[1\] sky130_fd_sc_hd__dfxtp_1
X_1262_ clknet_4_4_0_clk _0096_ VGND VGND VPWR VPWR u_sram.mem\[22\]\[0\] sky130_fd_sc_hd__dfxtp_1
XFILLER_0_6_301 VGND VGND VPWR VPWR sky130_fd_sc_hd__decap_4
X_0977_ _0343_ net81 _0392_ VGND VGND VPWR VPWR _0393_ sky130_fd_sc_hd__mux2_1
XFILLER_0_45_281 VPWR VGND VPWR VGND sky130_ef_sc_hd__decap_12
XFILLER_0_20_104 VGND VGND VPWR VPWR sky130_fd_sc_hd__decap_4
XFILLER_0_20_126 VGND VGND VPWR VPWR sky130_fd_sc_hd__decap_4
XPHY_90 VGND VGND VPWR VPWR sky130_fd_sc_hd__decap_3
X_0900_ _0304_ _0326_ u_addr_gen.addr\[4\] VGND VGND VPWR VPWR _0339_ sky130_fd_sc_hd__a21o_1
XFILLER_0_28_226 VGND VGND VPWR VPWR sky130_fd_sc_hd__fill_1
X_0762_ u_sram.mem\[3\]\[1\] _0179_ _0210_ u_sram.mem\[11\]\[1\] VGND VGND VPWR VPWR
+ _0211_ sky130_fd_sc_hd__a22o_1
X_0693_ u_fsm.state\[1\] VGND VGND VPWR VPWR _0150_ sky130_fd_sc_hd__inv_2
X_0831_ u_sram.mem\[58\]\[0\] _0199_ _0223_ _0278_ VGND VGND VPWR VPWR _0279_ sky130_fd_sc_hd__a31o_1
X_1314_ clknet_4_11_0_clk u_sram.read_req net12 VGND VGND VPWR VPWR u_sram.re_r sky130_fd_sc_hd__dfrtp_1
X_1176_ clknet_4_12_0_clk _0011_ net15 VGND VGND VPWR VPWR u_addr_gen.addr\[3\] sky130_fd_sc_hd__dfrtp_4
X_1245_ clknet_4_12_0_clk _0079_ VGND VGND VPWR VPWR u_sram.mem\[30\]\[1\] sky130_fd_sc_hd__dfxtp_1
XFILLER_0_2_77 VGND VGND VPWR VPWR sky130_fd_sc_hd__decap_6
XFILLER_0_34_218 VPWR VGND VPWR VGND sky130_ef_sc_hd__decap_12
XFILLER_0_42_251 VGND VGND VPWR VPWR sky130_fd_sc_hd__fill_1
XFILLER_0_17_23 VGND VGND VPWR VPWR sky130_fd_sc_hd__fill_2
XFILLER_0_17_45 VGND VGND VPWR VPWR sky130_fd_sc_hd__fill_2
X_1030_ _0363_ _0411_ VGND VGND VPWR VPWR _0428_ sky130_fd_sc_hd__nor2_1
XFILLER_0_33_55 VGND VGND VPWR VPWR sky130_fd_sc_hd__fill_1
X_0814_ u_sram.mem\[1\]\[0\] net11 _0165_ VGND VGND VPWR VPWR _0262_ sky130_fd_sc_hd__and3_1
X_0745_ _0171_ _0163_ _0172_ _0170_ VGND VGND VPWR VPWR _0194_ sky130_fd_sc_hd__and4b_4
X_0676_ _0570_ VGND VGND VPWR VPWR _0143_ sky130_fd_sc_hd__clkbuf_1
XFILLER_0_3_134 VGND VGND VPWR VPWR sky130_fd_sc_hd__fill_1
X_1228_ clknet_4_6_0_clk _0062_ VGND VGND VPWR VPWR u_sram.mem\[39\]\[0\] sky130_fd_sc_hd__dfxtp_1
XFILLER_0_28_3 VPWR VGND VPWR VGND sky130_ef_sc_hd__decap_12
X_1159_ _0508_ VGND VGND VPWR VPWR _0101_ sky130_fd_sc_hd__clkbuf_1
XFILLER_0_0_137 VGND VGND VPWR VPWR sky130_fd_sc_hd__decap_3
XFILLER_0_8_226 VGND VGND VPWR VPWR sky130_fd_sc_hd__decap_6
X_1013_ _0347_ _0411_ VGND VGND VPWR VPWR _0417_ sky130_fd_sc_hd__or2_1
X_0728_ _0172_ _0171_ _0163_ _0170_ VGND VGND VPWR VPWR _0177_ sky130_fd_sc_hd__nor4b_2
XFILLER_0_12_265 VPWR VGND VPWR VGND sky130_ef_sc_hd__decap_12
X_0659_ _0561_ VGND VGND VPWR VPWR _0135_ sky130_fd_sc_hd__clkbuf_1
Xclkbuf_4_8_0_clk clknet_0_clk VGND VGND VPWR VPWR clknet_4_8_0_clk sky130_fd_sc_hd__clkbuf_8
XFILLER_0_50_305 VGND VGND VPWR VPWR sky130_fd_sc_hd__fill_1
XFILLER_0_7_281 VPWR VGND VPWR VGND sky130_ef_sc_hd__decap_12
XFILLER_0_41_305 VGND VGND VPWR VPWR sky130_fd_sc_hd__fill_1
XFILLER_0_38_184 VGND VGND VPWR VPWR sky130_fd_sc_hd__fill_1
XFILLER_0_26_302 VGND VGND VPWR VPWR sky130_fd_sc_hd__decap_4
XFILLER_0_30_78 VGND VGND VPWR VPWR sky130_fd_sc_hd__fill_1
XFILLER_0_39_65 VGND VGND VPWR VPWR sky130_fd_sc_hd__decap_3
XFILLER_0_39_54 VGND VGND VPWR VPWR sky130_fd_sc_hd__fill_2
XTAP_202 VGND VPWR sky130_fd_sc_hd__tapvpwrvgnd_1
XTAP_213 VGND VPWR sky130_fd_sc_hd__tapvpwrvgnd_1
XTAP_224 VGND VPWR sky130_fd_sc_hd__tapvpwrvgnd_1
XTAP_235 VGND VPWR sky130_fd_sc_hd__tapvpwrvgnd_1
XTAP_246 VGND VPWR sky130_fd_sc_hd__tapvpwrvgnd_1
XTAP_257 VGND VPWR sky130_fd_sc_hd__tapvpwrvgnd_1
XTAP_279 VGND VPWR sky130_fd_sc_hd__tapvpwrvgnd_1
XTAP_268 VGND VPWR sky130_fd_sc_hd__tapvpwrvgnd_1
XFILLER_0_29_173 VGND VGND VPWR VPWR sky130_fd_sc_hd__fill_1
XFILLER_0_23_305 VGND VGND VPWR VPWR sky130_fd_sc_hd__fill_1
X_0993_ _0309_ _0332_ _0328_ VGND VGND VPWR VPWR _0403_ sky130_fd_sc_hd__or3_2
XFILLER_0_41_113 VGND VGND VPWR VPWR sky130_fd_sc_hd__fill_2
XFILLER_0_41_88 VGND VGND VPWR VPWR sky130_fd_sc_hd__fill_1
XFILLER_0_5_55 VGND VGND VPWR VPWR sky130_fd_sc_hd__fill_1
XFILLER_0_10_3 VPWR VGND VPWR VGND sky130_ef_sc_hd__decap_12
XFILLER_0_49_279 VGND VGND VPWR VPWR sky130_fd_sc_hd__fill_1
XFILLER_0_32_102 VGND VGND VPWR VPWR sky130_fd_sc_hd__decap_3
XFILLER_0_23_102 VGND VGND VPWR VPWR sky130_fd_sc_hd__decap_4
X_1261_ clknet_4_6_0_clk _0095_ VGND VGND VPWR VPWR u_sram.mem\[22\]\[1\] sky130_fd_sc_hd__dfxtp_1
XFILLER_0_36_66 VGND VGND VPWR VPWR sky130_fd_sc_hd__fill_2
X_1192_ clknet_4_3_0_clk _0026_ VGND VGND VPWR VPWR u_sram.mem\[57\]\[0\] sky130_fd_sc_hd__dfxtp_1
X_0976_ _0317_ _0391_ VGND VGND VPWR VPWR _0392_ sky130_fd_sc_hd__or2_1
XFILLER_0_45_293 VPWR VGND VPWR VGND sky130_ef_sc_hd__decap_12
XPHY_91 VGND VGND VPWR VPWR sky130_fd_sc_hd__decap_3
XPHY_80 VGND VGND VPWR VPWR sky130_fd_sc_hd__decap_3
XFILLER_0_22_46 VGND VGND VPWR VPWR sky130_fd_sc_hd__decap_8
X_0830_ u_sram.mem\[41\]\[0\] _0168_ _0204_ VGND VGND VPWR VPWR _0278_ sky130_fd_sc_hd__and3_1
XFILLER_0_28_238 VPWR VGND VPWR VGND sky130_ef_sc_hd__decap_12
X_0761_ u_sram.addr_r\[2\] _0171_ u_sram.addr_r\[1\] _0172_ VGND VGND VPWR VPWR _0210_
+ sky130_fd_sc_hd__and4b_4
XFILLER_0_3_305 VGND VGND VPWR VPWR sky130_fd_sc_hd__fill_1
XFILLER_0_11_149 VPWR VGND VPWR VGND sky130_ef_sc_hd__decap_12
X_0692_ u_fsm.state\[0\] u_fsm.state\[1\] VGND VGND VPWR VPWR _0149_ sky130_fd_sc_hd__nor2_1
X_1244_ clknet_4_5_0_clk _0078_ VGND VGND VPWR VPWR u_sram.mem\[31\]\[0\] sky130_fd_sc_hd__dfxtp_1
X_1313_ clknet_4_14_0_clk net27 net14 VGND VGND VPWR VPWR u_sram.addr_r\[5\] sky130_fd_sc_hd__dfrtp_1
X_1175_ clknet_4_13_0_clk _0010_ net15 VGND VGND VPWR VPWR u_addr_gen.addr\[2\] sky130_fd_sc_hd__dfrtp_2
XFILLER_0_42_230 VGND VGND VPWR VPWR sky130_fd_sc_hd__fill_1
X_0959_ net70 _0361_ _0380_ VGND VGND VPWR VPWR _0381_ sky130_fd_sc_hd__mux2_1
XFILLER_0_10_182 VGND VGND VPWR VPWR sky130_fd_sc_hd__fill_2
X_0813_ _0253_ _0255_ _0257_ _0260_ VGND VGND VPWR VPWR _0261_ sky130_fd_sc_hd__or4_1
XFILLER_0_3_113 VGND VGND VPWR VPWR sky130_fd_sc_hd__fill_2
XFILLER_0_16_219 VPWR VGND VPWR VGND sky130_ef_sc_hd__decap_12
X_0744_ u_sram.mem\[17\]\[1\] net163 _0185_ _0192_ VGND VGND VPWR VPWR _0193_ sky130_fd_sc_hd__a31o_1
X_0675_ _0308_ u_pattern_gen.state_r\[1\] _0155_ VGND VGND VPWR VPWR _0570_ sky130_fd_sc_hd__mux2_1
X_1227_ clknet_4_5_0_clk _0061_ VGND VGND VPWR VPWR u_sram.mem\[39\]\[1\] sky130_fd_sc_hd__dfxtp_1
X_1158_ net72 _0342_ _0507_ VGND VGND VPWR VPWR _0508_ sky130_fd_sc_hd__mux2_1
X_1089_ _0464_ VGND VGND VPWR VPWR _0075_ sky130_fd_sc_hd__clkbuf_1
XFILLER_0_30_277 VPWR VGND VPWR VGND sky130_ef_sc_hd__decap_12
XFILLER_0_21_222 VGND VGND VPWR VPWR sky130_fd_sc_hd__fill_2
XFILLER_0_21_244 VPWR VGND VPWR VGND sky130_ef_sc_hd__decap_12
X_1012_ _0416_ VGND VGND VPWR VPWR _0046_ sky130_fd_sc_hd__clkbuf_1
X_0727_ u_sram.mem\[36\]\[1\] _0174_ _0175_ u_sram.mem\[38\]\[1\] VGND VGND VPWR VPWR
+ _0176_ sky130_fd_sc_hd__a22o_1
XFILLER_0_40_3 VPWR VGND VPWR VGND sky130_ef_sc_hd__decap_12
X_0658_ _0308_ net110 _0560_ VGND VGND VPWR VPWR _0561_ sky130_fd_sc_hd__mux2_1
X_0589_ _0518_ VGND VGND VPWR VPWR _0108_ sky130_fd_sc_hd__clkbuf_1
XFILLER_0_7_293 VPWR VGND VPWR VGND sky130_ef_sc_hd__decap_12
XFILLER_0_38_152 VPWR VGND VPWR VGND sky130_ef_sc_hd__decap_12
XFILLER_0_39_88 VGND VGND VPWR VPWR sky130_fd_sc_hd__fill_1
XTAP_269 VGND VPWR sky130_fd_sc_hd__tapvpwrvgnd_1
XTAP_203 VGND VPWR sky130_fd_sc_hd__tapvpwrvgnd_1
XTAP_214 VGND VPWR sky130_fd_sc_hd__tapvpwrvgnd_1
XTAP_225 VGND VPWR sky130_fd_sc_hd__tapvpwrvgnd_1
XTAP_236 VGND VPWR sky130_fd_sc_hd__tapvpwrvgnd_1
XTAP_247 VGND VPWR sky130_fd_sc_hd__tapvpwrvgnd_1
XTAP_258 VGND VPWR sky130_fd_sc_hd__tapvpwrvgnd_1
XFILLER_0_44_111 VGND VGND VPWR VPWR sky130_fd_sc_hd__decap_4
XFILLER_0_29_130 VPWR VGND VPWR VGND sky130_ef_sc_hd__decap_12
XFILLER_0_35_111 VGND VGND VPWR VPWR sky130_fd_sc_hd__fill_1
XFILLER_0_25_35 VGND VGND VPWR VPWR sky130_fd_sc_hd__decap_3
XFILLER_0_25_57 VPWR VGND VPWR VGND sky130_ef_sc_hd__decap_12
X_0992_ _0402_ VGND VGND VPWR VPWR _0040_ sky130_fd_sc_hd__clkbuf_1
Xclkbuf_4_7_0_clk clknet_0_clk VGND VGND VPWR VPWR clknet_4_7_0_clk sky130_fd_sc_hd__clkbuf_8
XFILLER_0_49_225 VPWR VGND VPWR VGND sky130_ef_sc_hd__decap_12
XFILLER_0_11_15 VPWR VGND VPWR VGND sky130_ef_sc_hd__decap_12
X_1260_ clknet_4_4_0_clk _0094_ VGND VGND VPWR VPWR u_sram.mem\[23\]\[0\] sky130_fd_sc_hd__dfxtp_1
X_1191_ clknet_4_3_0_clk _0025_ VGND VGND VPWR VPWR u_sram.mem\[57\]\[1\] sky130_fd_sc_hd__dfxtp_1
XFILLER_0_46_206 VPWR VGND VPWR VGND sky130_ef_sc_hd__decap_12
X_0975_ _0310_ _0311_ u_addr_gen.addr\[3\] u_addr_gen.addr\[2\] VGND VGND VPWR VPWR
+ _0391_ sky130_fd_sc_hd__or4b_4
XFILLER_0_45_261 VPWR VGND VPWR VGND sky130_ef_sc_hd__decap_12
XFILLER_0_20_139 VGND VGND VPWR VPWR sky130_fd_sc_hd__fill_1
XPHY_92 VGND VGND VPWR VPWR sky130_fd_sc_hd__decap_3
XFILLER_0_43_209 VPWR VGND VPWR VGND sky130_ef_sc_hd__decap_12
XPHY_81 VGND VGND VPWR VPWR sky130_fd_sc_hd__decap_3
XPHY_70 VGND VGND VPWR VPWR sky130_fd_sc_hd__decap_3
X_0760_ u_sram.mem\[12\]\[1\] _0200_ _0194_ u_sram.mem\[7\]\[1\] VGND VGND VPWR VPWR
+ _0209_ sky130_fd_sc_hd__a22o_1
XFILLER_0_51_253 VPWR VGND VPWR VGND sky130_ef_sc_hd__decap_12
X_0691_ u_fsm.state\[2\] u_fsm.state\[0\] u_fsm.state\[1\] VGND VGND VPWR VPWR _0148_
+ sky130_fd_sc_hd__and3b_1
XFILLER_0_47_77 VGND VGND VPWR VPWR sky130_fd_sc_hd__decap_3
XFILLER_0_47_55 VGND VGND VPWR VPWR sky130_fd_sc_hd__fill_1
X_1243_ clknet_4_5_0_clk _0077_ VGND VGND VPWR VPWR u_sram.mem\[31\]\[1\] sky130_fd_sc_hd__dfxtp_1
X_1174_ clknet_4_13_0_clk _0009_ net15 VGND VGND VPWR VPWR u_addr_gen.addr\[1\] sky130_fd_sc_hd__dfrtp_1
X_1312_ clknet_4_14_0_clk net26 net14 VGND VGND VPWR VPWR u_sram.addr_r\[4\] sky130_fd_sc_hd__dfrtp_1
XFILLER_0_42_253 VPWR VGND VPWR VGND sky130_ef_sc_hd__decap_12
X_0889_ _0328_ _0330_ _0311_ _0327_ VGND VGND VPWR VPWR _0009_ sky130_fd_sc_hd__a2bb2o_1
X_0958_ _0317_ _0337_ VGND VGND VPWR VPWR _0380_ sky130_fd_sc_hd__nor2_1
XFILLER_0_33_57 VPWR VGND VPWR VGND sky130_ef_sc_hd__decap_12
X_0743_ u_sram.mem\[40\]\[1\] _0168_ net5 VGND VGND VPWR VPWR _0192_ sky130_fd_sc_hd__and3_1
X_0812_ _0169_ _0258_ _0259_ _0185_ VGND VGND VPWR VPWR _0260_ sky130_fd_sc_hd__a22o_1
XFILLER_0_3_169 VGND VGND VPWR VPWR sky130_fd_sc_hd__fill_1
XFILLER_0_24_253 VGND VGND VPWR VPWR sky130_fd_sc_hd__fill_1
X_0674_ _0351_ _0155_ VGND VGND VPWR VPWR _0142_ sky130_fd_sc_hd__xnor2_1
X_1226_ clknet_4_6_0_clk _0060_ VGND VGND VPWR VPWR u_sram.mem\[40\]\[0\] sky130_fd_sc_hd__dfxtp_1
X_1157_ _0395_ _0468_ VGND VGND VPWR VPWR _0507_ sky130_fd_sc_hd__nor2_1
X_1088_ _0424_ net101 _0463_ VGND VGND VPWR VPWR _0464_ sky130_fd_sc_hd__mux2_1
XFILLER_0_30_289 VPWR VGND VPWR VGND sky130_ef_sc_hd__decap_12
XFILLER_0_30_267 VGND VGND VPWR VPWR sky130_fd_sc_hd__fill_2
XFILLER_0_15_231 VGND VGND VPWR VPWR sky130_fd_sc_hd__decap_6
XFILLER_0_38_301 VGND VGND VPWR VPWR sky130_fd_sc_hd__decap_4
XFILLER_0_21_256 VGND VGND VPWR VPWR sky130_fd_sc_hd__decap_8
XFILLER_0_21_278 VGND VGND VPWR VPWR sky130_fd_sc_hd__fill_2
X_1011_ net153 _0366_ _0414_ VGND VGND VPWR VPWR _0416_ sky130_fd_sc_hd__mux2_1
X_0726_ _0172_ _0171_ u_sram.addr_r\[2\] _0170_ VGND VGND VPWR VPWR _0175_ sky130_fd_sc_hd__and4bb_4
XFILLER_0_33_3 VPWR VGND VPWR VGND sky130_ef_sc_hd__decap_12
X_0657_ _0399_ _0520_ VGND VGND VPWR VPWR _0560_ sky130_fd_sc_hd__or2_1
X_0588_ _0492_ net47 _0516_ VGND VGND VPWR VPWR _0518_ sky130_fd_sc_hd__mux2_1
X_1209_ clknet_4_8_0_clk _0043_ VGND VGND VPWR VPWR u_sram.mem\[48\]\[1\] sky130_fd_sc_hd__dfxtp_1
XFILLER_0_38_197 VPWR VGND VPWR VGND sky130_ef_sc_hd__decap_12
XFILLER_0_38_164 VPWR VGND VPWR VGND sky130_ef_sc_hd__decap_12
XTAP_204 VGND VPWR sky130_fd_sc_hd__tapvpwrvgnd_1
XTAP_215 VGND VPWR sky130_fd_sc_hd__tapvpwrvgnd_1
XTAP_226 VGND VPWR sky130_fd_sc_hd__tapvpwrvgnd_1
XTAP_237 VGND VPWR sky130_fd_sc_hd__tapvpwrvgnd_1
XTAP_248 VGND VPWR sky130_fd_sc_hd__tapvpwrvgnd_1
XTAP_259 VGND VPWR sky130_fd_sc_hd__tapvpwrvgnd_1
XFILLER_0_44_167 VPWR VGND VPWR VGND sky130_ef_sc_hd__decap_12
XFILLER_0_29_142 VPWR VGND VPWR VGND sky130_ef_sc_hd__decap_12
XFILLER_0_4_253 VPWR VGND VPWR VGND sky130_ef_sc_hd__decap_12
X_0709_ u_fsm.state\[2\] net28 _0149_ _0160_ VGND VGND VPWR VPWR u_fsm.next_state\[0\]
+ sky130_fd_sc_hd__a31o_1
XFILLER_0_35_123 VGND VGND VPWR VPWR sky130_fd_sc_hd__fill_2
XFILLER_0_25_69 VPWR VGND VPWR VGND sky130_ef_sc_hd__decap_12
X_0991_ _0351_ net145 _0400_ VGND VGND VPWR VPWR _0402_ sky130_fd_sc_hd__mux2_1
XFILLER_0_26_134 VGND VGND VPWR VPWR sky130_fd_sc_hd__fill_1
XFILLER_0_26_156 VGND VGND VPWR VPWR sky130_fd_sc_hd__fill_1
XFILLER_0_5_57 VPWR VGND VPWR VGND sky130_ef_sc_hd__decap_12
XFILLER_0_49_237 VPWR VGND VPWR VGND sky130_ef_sc_hd__decap_12
XFILLER_0_9_301 VGND VGND VPWR VPWR sky130_fd_sc_hd__decap_4
XFILLER_0_32_126 VGND VGND VPWR VPWR sky130_fd_sc_hd__decap_4
XFILLER_0_17_145 VGND VGND VPWR VPWR sky130_fd_sc_hd__fill_1
XFILLER_0_11_27 VGND VGND VPWR VPWR sky130_fd_sc_hd__decap_8
XFILLER_0_11_49 VGND VGND VPWR VPWR sky130_fd_sc_hd__decap_6
XFILLER_0_23_159 VGND VGND VPWR VPWR sky130_fd_sc_hd__fill_1
X_1190_ clknet_4_3_0_clk _0024_ VGND VGND VPWR VPWR u_sram.mem\[58\]\[0\] sky130_fd_sc_hd__dfxtp_1
XFILLER_0_46_218 VPWR VGND VPWR VGND sky130_ef_sc_hd__decap_12
XFILLER_0_39_281 VPWR VGND VPWR VGND sky130_ef_sc_hd__decap_12
X_0974_ _0390_ VGND VGND VPWR VPWR _0034_ sky130_fd_sc_hd__clkbuf_1
XFILLER_0_45_273 VGND VGND VPWR VPWR sky130_fd_sc_hd__decap_6
XFILLER_0_9_186 VGND VGND VPWR VPWR sky130_fd_sc_hd__fill_2
XPHY_82 VGND VGND VPWR VPWR sky130_fd_sc_hd__decap_3
XPHY_71 VGND VGND VPWR VPWR sky130_fd_sc_hd__decap_3
XPHY_60 VGND VGND VPWR VPWR sky130_fd_sc_hd__decap_3
XFILLER_0_51_265 VPWR VGND VPWR VGND sky130_ef_sc_hd__decap_12
XFILLER_0_51_221 VGND VGND VPWR VPWR sky130_fd_sc_hd__decap_3
XPHY_93 VGND VGND VPWR VPWR sky130_fd_sc_hd__decap_3
Xclkbuf_4_6_0_clk clknet_0_clk VGND VGND VPWR VPWR clknet_4_6_0_clk sky130_fd_sc_hd__clkbuf_8
XFILLER_0_36_251 VGND VGND VPWR VPWR sky130_fd_sc_hd__fill_1
X_0690_ _0580_ VGND VGND VPWR VPWR _0147_ sky130_fd_sc_hd__clkbuf_1
X_1311_ clknet_4_12_0_clk net23 net15 VGND VGND VPWR VPWR u_sram.addr_r\[3\] sky130_fd_sc_hd__dfrtp_4
XFILLER_0_11_107 VGND VGND VPWR VPWR sky130_fd_sc_hd__decap_4
X_1242_ clknet_4_13_0_clk _0076_ VGND VGND VPWR VPWR u_sram.mem\[32\]\[0\] sky130_fd_sc_hd__dfxtp_1
X_1173_ clknet_4_13_0_clk _0008_ net15 VGND VGND VPWR VPWR u_addr_gen.addr\[0\] sky130_fd_sc_hd__dfrtp_1
XFILLER_0_6_101 VPWR VGND VPWR VGND sky130_ef_sc_hd__decap_12
XFILLER_0_42_265 VPWR VGND VPWR VGND sky130_ef_sc_hd__decap_12
X_0888_ _0329_ _0326_ VGND VGND VPWR VPWR _0330_ sky130_fd_sc_hd__nand2_1
X_0957_ _0379_ VGND VGND VPWR VPWR _0028_ sky130_fd_sc_hd__clkbuf_1
XFILLER_0_10_173 VGND VGND VPWR VPWR sky130_fd_sc_hd__decap_3
XFILLER_0_17_15 VGND VGND VPWR VPWR sky130_fd_sc_hd__decap_4
XFILLER_0_33_69 VPWR VGND VPWR VGND sky130_ef_sc_hd__decap_12
X_0742_ u_sram.mem\[47\]\[1\] _0169_ _0189_ _0190_ VGND VGND VPWR VPWR _0191_ sky130_fd_sc_hd__a31o_1
X_0673_ _0569_ VGND VGND VPWR VPWR _0141_ sky130_fd_sc_hd__clkbuf_1
X_0811_ u_sram.mem\[18\]\[0\] net6 _0194_ u_sram.mem\[23\]\[0\] VGND VGND VPWR VPWR
+ _0259_ sky130_fd_sc_hd__a22o_1
X_1087_ _0407_ _0413_ VGND VGND VPWR VPWR _0463_ sky130_fd_sc_hd__or2_1
X_1225_ clknet_4_6_0_clk _0059_ VGND VGND VPWR VPWR u_sram.mem\[40\]\[1\] sky130_fd_sc_hd__dfxtp_1
X_1156_ _0506_ VGND VGND VPWR VPWR _0100_ sky130_fd_sc_hd__clkbuf_1
XFILLER_0_2_192 VGND VGND VPWR VPWR sky130_fd_sc_hd__fill_1
XFILLER_0_15_276 VGND VGND VPWR VPWR sky130_fd_sc_hd__decap_4
X_1010_ _0415_ VGND VGND VPWR VPWR _0045_ sky130_fd_sc_hd__clkbuf_1
XFILLER_0_44_305 VGND VGND VPWR VPWR sky130_fd_sc_hd__fill_1
X_0725_ _0172_ _0170_ _0171_ _0163_ VGND VGND VPWR VPWR _0174_ sky130_fd_sc_hd__nor4b_2
X_0656_ _0559_ VGND VGND VPWR VPWR _0134_ sky130_fd_sc_hd__clkbuf_1
X_1208_ clknet_4_10_0_clk _0042_ VGND VGND VPWR VPWR u_sram.mem\[49\]\[0\] sky130_fd_sc_hd__dfxtp_1
XFILLER_0_26_3 VPWR VGND VPWR VGND sky130_ef_sc_hd__decap_12
X_0587_ _0517_ VGND VGND VPWR VPWR _0107_ sky130_fd_sc_hd__clkbuf_1
XFILLER_0_35_305 VGND VGND VPWR VPWR sky130_fd_sc_hd__fill_1
X_1139_ net49 _0437_ _0494_ VGND VGND VPWR VPWR _0496_ sky130_fd_sc_hd__mux2_1
XFILLER_0_38_176 VGND VGND VPWR VPWR sky130_fd_sc_hd__decap_8
XFILLER_0_39_35 VGND VGND VPWR VPWR sky130_fd_sc_hd__decap_3
XTAP_205 VGND VPWR sky130_fd_sc_hd__tapvpwrvgnd_1
Xhold1 u_addr_gen.addr\[1\] VGND VGND VPWR VPWR net17 sky130_fd_sc_hd__dlygate4sd3_1
XTAP_216 VGND VPWR sky130_fd_sc_hd__tapvpwrvgnd_1
XTAP_227 VGND VPWR sky130_fd_sc_hd__tapvpwrvgnd_1
XTAP_238 VGND VPWR sky130_fd_sc_hd__tapvpwrvgnd_1
XTAP_249 VGND VPWR sky130_fd_sc_hd__tapvpwrvgnd_1
XFILLER_0_29_154 VGND VGND VPWR VPWR sky130_fd_sc_hd__decap_8
XFILLER_0_44_179 VPWR VGND VPWR VGND sky130_ef_sc_hd__decap_12
XFILLER_0_4_265 VPWR VGND VPWR VGND sky130_ef_sc_hd__decap_12
XFILLER_0_4_232 VPWR VGND VPWR VGND sky130_ef_sc_hd__decap_12
XFILLER_0_17_305 VGND VGND VPWR VPWR sky130_fd_sc_hd__fill_1
X_0639_ _0549_ VGND VGND VPWR VPWR _0127_ sky130_fd_sc_hd__clkbuf_1
XFILLER_0_20_92 VPWR VGND VPWR VGND sky130_ef_sc_hd__decap_12
X_0708_ _0159_ _0151_ _0154_ _0002_ VGND VGND VPWR VPWR _0160_ sky130_fd_sc_hd__a211o_1
XFILLER_0_35_113 VGND VGND VPWR VPWR sky130_fd_sc_hd__fill_1
XFILLER_0_25_15 VPWR VGND VPWR VGND sky130_ef_sc_hd__decap_12
XFILLER_0_41_105 VGND VGND VPWR VPWR sky130_fd_sc_hd__fill_2
X_0990_ _0401_ VGND VGND VPWR VPWR _0039_ sky130_fd_sc_hd__clkbuf_1
XFILLER_0_5_69 VPWR VGND VPWR VGND sky130_ef_sc_hd__decap_12
XFILLER_0_1_279 VGND VGND VPWR VPWR sky130_fd_sc_hd__fill_1
XFILLER_0_49_205 VPWR VGND VPWR VGND sky130_ef_sc_hd__decap_12
XFILLER_0_49_249 VPWR VGND VPWR VGND sky130_ef_sc_hd__decap_12
XFILLER_0_17_124 VPWR VGND VPWR VGND sky130_ef_sc_hd__decap_12
XFILLER_0_23_138 VPWR VGND VPWR VGND sky130_ef_sc_hd__decap_12
XFILLER_0_39_293 VPWR VGND VPWR VGND sky130_ef_sc_hd__decap_12
XFILLER_0_6_305 VGND VGND VPWR VPWR sky130_fd_sc_hd__fill_1
X_0973_ net75 _0366_ _0388_ VGND VGND VPWR VPWR _0390_ sky130_fd_sc_hd__mux2_1
XFILLER_0_20_108 VGND VGND VPWR VPWR sky130_fd_sc_hd__fill_1
XPHY_94 VGND VGND VPWR VPWR sky130_fd_sc_hd__decap_3
XPHY_83 VGND VGND VPWR VPWR sky130_fd_sc_hd__decap_3
XPHY_72 VGND VGND VPWR VPWR sky130_fd_sc_hd__decap_3
XPHY_61 VGND VGND VPWR VPWR sky130_fd_sc_hd__decap_3
XPHY_50 VGND VGND VPWR VPWR sky130_fd_sc_hd__decap_3
XFILLER_0_51_277 VGND VGND VPWR VPWR sky130_fd_sc_hd__decap_3
XFILLER_0_47_57 VPWR VGND VPWR VGND sky130_ef_sc_hd__decap_12
X_1241_ clknet_4_13_0_clk _0075_ VGND VGND VPWR VPWR u_sram.mem\[32\]\[1\] sky130_fd_sc_hd__dfxtp_1
X_1310_ clknet_4_13_0_clk net22 net15 VGND VGND VPWR VPWR u_sram.addr_r\[2\] sky130_fd_sc_hd__dfrtp_4
XFILLER_0_2_15 VPWR VGND VPWR VGND sky130_ef_sc_hd__decap_12
X_1172_ clknet_4_14_0_clk _0001_ net16 VGND VGND VPWR VPWR u_addr_gen.state\[1\] sky130_fd_sc_hd__dfrtp_1
XFILLER_0_42_222 VGND VGND VPWR VPWR sky130_fd_sc_hd__decap_8
XFILLER_0_6_113 VGND VGND VPWR VPWR sky130_fd_sc_hd__decap_6
X_0956_ _0351_ net143 _0377_ VGND VGND VPWR VPWR _0379_ sky130_fd_sc_hd__mux2_1
XFILLER_0_42_277 VPWR VGND VPWR VGND sky130_ef_sc_hd__decap_12
X_0887_ u_addr_gen.state\[1\] _0302_ VGND VGND VPWR VPWR _0329_ sky130_fd_sc_hd__and2_1
XFILLER_0_37_90 VGND VGND VPWR VPWR sky130_fd_sc_hd__decap_8
XFILLER_0_33_233 VGND VGND VPWR VPWR sky130_fd_sc_hd__fill_2
XFILLER_0_33_15 VPWR VGND VPWR VGND sky130_ef_sc_hd__decap_12
X_0810_ u_sram.mem\[42\]\[0\] _0199_ _0200_ u_sram.mem\[44\]\[0\] VGND VGND VPWR VPWR
+ _0258_ sky130_fd_sc_hd__a22o_1
X_0741_ u_sram.mem\[21\]\[1\] _0173_ _0184_ VGND VGND VPWR VPWR _0190_ sky130_fd_sc_hd__and3_1
XFILLER_0_3_105 VGND VGND VPWR VPWR sky130_fd_sc_hd__decap_6
X_0672_ net24 VGND VGND VPWR VPWR _0569_ sky130_fd_sc_hd__clkbuf_1
X_1224_ clknet_4_1_0_clk _0058_ VGND VGND VPWR VPWR u_sram.mem\[41\]\[0\] sky130_fd_sc_hd__dfxtp_1
X_1086_ _0462_ VGND VGND VPWR VPWR _0074_ sky130_fd_sc_hd__clkbuf_1
X_1155_ _0492_ net114 _0504_ VGND VGND VPWR VPWR _0506_ sky130_fd_sc_hd__mux2_1
X_0939_ _0367_ VGND VGND VPWR VPWR _0022_ sky130_fd_sc_hd__clkbuf_1
XFILLER_0_23_81 VGND VGND VPWR VPWR sky130_fd_sc_hd__decap_4
Xclkbuf_4_5_0_clk clknet_0_clk VGND VGND VPWR VPWR clknet_4_5_0_clk sky130_fd_sc_hd__clkbuf_8
XFILLER_0_28_15 VPWR VGND VPWR VGND sky130_ef_sc_hd__decap_12
X_0724_ _0170_ _0171_ _0163_ _0172_ VGND VGND VPWR VPWR _0173_ sky130_fd_sc_hd__and4bb_4
X_0655_ _0320_ net160 _0557_ VGND VGND VPWR VPWR _0559_ sky130_fd_sc_hd__mux2_1
X_0586_ _0503_ net44 _0516_ VGND VGND VPWR VPWR _0517_ sky130_fd_sc_hd__mux2_1
X_1207_ clknet_4_8_0_clk _0041_ VGND VGND VPWR VPWR u_sram.mem\[49\]\[1\] sky130_fd_sc_hd__dfxtp_1
XFILLER_0_19_3 VPWR VGND VPWR VGND sky130_ef_sc_hd__decap_12
X_1069_ _0452_ VGND VGND VPWR VPWR _0067_ sky130_fd_sc_hd__clkbuf_1
XFILLER_0_34_80 VGND VGND VPWR VPWR sky130_fd_sc_hd__decap_4
X_1138_ _0495_ VGND VGND VPWR VPWR _0093_ sky130_fd_sc_hd__clkbuf_1
XFILLER_0_14_17 VGND VGND VPWR VPWR sky130_fd_sc_hd__decap_4
XFILLER_0_30_38 VGND VGND VPWR VPWR sky130_fd_sc_hd__fill_1
XTAP_206 VGND VPWR sky130_fd_sc_hd__tapvpwrvgnd_1
XTAP_217 VGND VPWR sky130_fd_sc_hd__tapvpwrvgnd_1
XTAP_228 VGND VPWR sky130_fd_sc_hd__tapvpwrvgnd_1
XTAP_239 VGND VPWR sky130_fd_sc_hd__tapvpwrvgnd_1
Xhold2 u_sram.re_r VGND VGND VPWR VPWR net18 sky130_fd_sc_hd__buf_1
XFILLER_0_4_277 VPWR VGND VPWR VGND sky130_ef_sc_hd__decap_12
XFILLER_0_4_244 VGND VGND VPWR VPWR sky130_fd_sc_hd__decap_8
XFILLER_0_20_82 VGND VGND VPWR VPWR sky130_fd_sc_hd__fill_2
X_0707_ u_fsm.addr_done_seen VGND VGND VPWR VPWR _0159_ sky130_fd_sc_hd__inv_2
X_0638_ _0308_ net148 _0548_ VGND VGND VPWR VPWR _0549_ sky130_fd_sc_hd__mux2_1
XFILLER_0_35_169 VGND VGND VPWR VPWR sky130_fd_sc_hd__decap_4
XFILLER_0_0_81 VGND VGND VPWR VPWR sky130_fd_sc_hd__decap_3
XFILLER_0_8_3 VPWR VGND VPWR VGND sky130_ef_sc_hd__decap_12
XFILLER_0_25_27 VGND VGND VPWR VPWR sky130_fd_sc_hd__decap_8
XFILLER_0_41_15 VPWR VGND VPWR VGND sky130_ef_sc_hd__decap_12
XFILLER_0_25_49 VGND VGND VPWR VPWR sky130_fd_sc_hd__decap_6
XFILLER_0_1_225 VPWR VGND VPWR VGND sky130_ef_sc_hd__decap_12
XFILLER_0_5_15 VPWR VGND VPWR VGND sky130_ef_sc_hd__decap_12
XFILLER_0_49_217 VGND VGND VPWR VPWR sky130_fd_sc_hd__decap_6
XFILLER_0_17_136 VGND VGND VPWR VPWR sky130_fd_sc_hd__fill_2
XFILLER_0_17_169 VGND VGND VPWR VPWR sky130_fd_sc_hd__decap_3
XFILLER_0_40_194 VGND VGND VPWR VPWR sky130_fd_sc_hd__fill_2
XFILLER_0_23_106 VGND VGND VPWR VPWR sky130_fd_sc_hd__fill_1
XFILLER_0_36_15 VPWR VGND VPWR VGND sky130_ef_sc_hd__decap_12
X_0972_ _0389_ VGND VGND VPWR VPWR _0033_ sky130_fd_sc_hd__clkbuf_1
XFILLER_0_42_91 VGND VGND VPWR VPWR sky130_fd_sc_hd__fill_1
XPHY_95 VGND VGND VPWR VPWR sky130_fd_sc_hd__decap_3
XPHY_84 VGND VGND VPWR VPWR sky130_fd_sc_hd__decap_3
XPHY_73 VGND VGND VPWR VPWR sky130_fd_sc_hd__decap_3
XFILLER_0_36_253 VPWR VGND VPWR VGND sky130_ef_sc_hd__decap_12
XPHY_62 VGND VGND VPWR VPWR sky130_fd_sc_hd__decap_3
XPHY_40 VGND VGND VPWR VPWR sky130_fd_sc_hd__decap_3
XPHY_51 VGND VGND VPWR VPWR sky130_fd_sc_hd__decap_3
X_1240_ clknet_4_7_0_clk _0074_ VGND VGND VPWR VPWR u_sram.mem\[33\]\[0\] sky130_fd_sc_hd__dfxtp_1
XFILLER_0_47_69 VGND VGND VPWR VPWR sky130_fd_sc_hd__decap_8
X_1171_ clknet_4_14_0_clk _0000_ net16 VGND VGND VPWR VPWR u_addr_gen.state\[0\] sky130_fd_sc_hd__dfstp_1
XFILLER_0_2_27 VGND VGND VPWR VPWR sky130_fd_sc_hd__fill_1
X_0886_ _0311_ _0310_ VGND VGND VPWR VPWR _0328_ sky130_fd_sc_hd__or2b_1
X_0955_ _0378_ VGND VGND VPWR VPWR _0027_ sky130_fd_sc_hd__clkbuf_1
XFILLER_0_27_242 VPWR VGND VPWR VGND sky130_ef_sc_hd__decap_12
XFILLER_0_27_297 VGND VGND VPWR VPWR sky130_fd_sc_hd__decap_8
XFILLER_0_42_289 VPWR VGND VPWR VGND sky130_ef_sc_hd__decap_12
XFILLER_0_49_3 VPWR VGND VPWR VGND sky130_ef_sc_hd__decap_12
XFILLER_0_18_253 VPWR VGND VPWR VGND sky130_ef_sc_hd__decap_12
XFILLER_0_33_27 VPWR VGND VPWR VGND sky130_ef_sc_hd__decap_12
X_0740_ _0172_ _0170_ _0171_ _0163_ VGND VGND VPWR VPWR _0189_ sky130_fd_sc_hd__and4_4
X_0671_ _0568_ VGND VGND VPWR VPWR _0140_ sky130_fd_sc_hd__clkbuf_1
XFILLER_0_24_278 VPWR VGND VPWR VGND sky130_ef_sc_hd__decap_12
X_1223_ clknet_4_3_0_clk _0057_ VGND VGND VPWR VPWR u_sram.mem\[41\]\[1\] sky130_fd_sc_hd__dfxtp_1
X_1154_ _0505_ VGND VGND VPWR VPWR _0099_ sky130_fd_sc_hd__clkbuf_1
X_1085_ _0422_ net131 _0460_ VGND VGND VPWR VPWR _0462_ sky130_fd_sc_hd__mux2_1
X_0938_ net88 _0366_ _0364_ VGND VGND VPWR VPWR _0367_ sky130_fd_sc_hd__mux2_1
X_0869_ u_addr_gen.addr\[4\] u_addr_gen.addr\[5\] net14 VGND VGND VPWR VPWR _0314_
+ sky130_fd_sc_hd__nand3_4
XFILLER_0_30_237 VPWR VGND VPWR VGND sky130_ef_sc_hd__decap_12
XFILLER_0_3_81 VPWR VGND VPWR VGND sky130_ef_sc_hd__decap_12
XFILLER_0_0_109 VGND VGND VPWR VPWR sky130_fd_sc_hd__decap_3
XFILLER_0_44_15 VPWR VGND VPWR VGND sky130_ef_sc_hd__decap_12
XFILLER_0_28_27 VGND VGND VPWR VPWR sky130_fd_sc_hd__fill_1
X_0723_ u_sram.addr_r\[0\] VGND VGND VPWR VPWR _0172_ sky130_fd_sc_hd__buf_2
XFILLER_0_8_15 VPWR VGND VPWR VGND sky130_ef_sc_hd__decap_12
XFILLER_0_12_215 VGND VGND VPWR VPWR sky130_fd_sc_hd__fill_1
X_0585_ _0407_ _0468_ VGND VGND VPWR VPWR _0516_ sky130_fd_sc_hd__or2_1
X_0654_ _0558_ VGND VGND VPWR VPWR _0133_ sky130_fd_sc_hd__clkbuf_1
XFILLER_0_20_281 VGND VGND VPWR VPWR sky130_fd_sc_hd__decap_8
X_1137_ net67 _0434_ _0494_ VGND VGND VPWR VPWR _0495_ sky130_fd_sc_hd__mux2_1
X_1206_ clknet_4_10_0_clk _0040_ VGND VGND VPWR VPWR u_sram.mem\[50\]\[0\] sky130_fd_sc_hd__dfxtp_1
XFILLER_0_18_82 VGND VGND VPWR VPWR sky130_fd_sc_hd__fill_2
X_1068_ _0424_ net84 _0451_ VGND VGND VPWR VPWR _0452_ sky130_fd_sc_hd__mux2_1
XFILLER_0_11_281 VGND VGND VPWR VPWR sky130_fd_sc_hd__fill_1
XFILLER_0_39_15 VPWR VGND VPWR VGND sky130_ef_sc_hd__decap_12
XTAP_207 VGND VPWR sky130_fd_sc_hd__tapvpwrvgnd_1
XTAP_218 VGND VPWR sky130_fd_sc_hd__tapvpwrvgnd_1
XTAP_229 VGND VPWR sky130_fd_sc_hd__tapvpwrvgnd_1
Xhold3 u_addr_gen.addr\[0\] VGND VGND VPWR VPWR net19 sky130_fd_sc_hd__dlygate4sd3_1
Xclkbuf_4_4_0_clk clknet_0_clk VGND VGND VPWR VPWR clknet_4_4_0_clk sky130_fd_sc_hd__clkbuf_8
XFILLER_0_4_289 VPWR VGND VPWR VGND sky130_ef_sc_hd__decap_12
X_0706_ _0158_ VGND VGND VPWR VPWR _0002_ sky130_fd_sc_hd__buf_1
XFILLER_0_31_3 VPWR VGND VPWR VGND sky130_ef_sc_hd__decap_12
X_0637_ _0383_ _0520_ VGND VGND VPWR VPWR _0548_ sky130_fd_sc_hd__or2_1
XFILLER_0_9_91 VGND VGND VPWR VPWR sky130_fd_sc_hd__fill_1
XFILLER_0_1_237 VPWR VGND VPWR VGND sky130_ef_sc_hd__decap_12
XFILLER_0_5_27 VPWR VGND VPWR VGND sky130_ef_sc_hd__decap_12
XFILLER_0_0_270 VGND VGND VPWR VPWR sky130_fd_sc_hd__decap_8
XFILLER_0_0_281 VPWR VGND VPWR VGND sky130_ef_sc_hd__decap_12
XFILLER_0_16_192 VGND VGND VPWR VPWR sky130_fd_sc_hd__decap_4
XFILLER_0_36_27 VGND VGND VPWR VPWR sky130_fd_sc_hd__fill_1
X_0971_ net118 _0361_ _0388_ VGND VGND VPWR VPWR _0389_ sky130_fd_sc_hd__mux2_1
XFILLER_0_22_195 VGND VGND VPWR VPWR sky130_fd_sc_hd__fill_1
XFILLER_0_45_221 VGND VGND VPWR VPWR sky130_fd_sc_hd__decap_3
XPHY_30 VGND VGND VPWR VPWR sky130_fd_sc_hd__decap_3
XPHY_96 VGND VGND VPWR VPWR sky130_fd_sc_hd__decap_3
XPHY_85 VGND VGND VPWR VPWR sky130_fd_sc_hd__decap_3
XPHY_74 VGND VGND VPWR VPWR sky130_fd_sc_hd__decap_3
XFILLER_0_36_265 VPWR VGND VPWR VGND sky130_ef_sc_hd__decap_12
XPHY_63 VGND VGND VPWR VPWR sky130_fd_sc_hd__decap_3
XPHY_41 VGND VGND VPWR VPWR sky130_fd_sc_hd__decap_3
XPHY_52 VGND VGND VPWR VPWR sky130_fd_sc_hd__decap_3
XFILLER_0_47_15 VPWR VGND VPWR VGND sky130_ef_sc_hd__decap_12
X_1170_ clknet_4_2_0_clk _0007_ VGND VGND VPWR VPWR u_sram.mem\[63\]\[0\] sky130_fd_sc_hd__dfxtp_1
X_0885_ _0310_ _0326_ _0327_ VGND VGND VPWR VPWR _0008_ sky130_fd_sc_hd__o21a_1
XFILLER_0_6_137 VGND VGND VPWR VPWR sky130_fd_sc_hd__decap_3
X_0954_ _0343_ net124 _0377_ VGND VGND VPWR VPWR _0378_ sky130_fd_sc_hd__mux2_1
XFILLER_0_27_254 VGND VGND VPWR VPWR sky130_fd_sc_hd__fill_2
X_1299_ clknet_4_2_0_clk _0133_ VGND VGND VPWR VPWR u_sram.mem\[3\]\[1\] sky130_fd_sc_hd__dfxtp_1
XFILLER_0_18_265 VGND VGND VPWR VPWR sky130_fd_sc_hd__decap_4
XFILLER_0_33_279 VGND VGND VPWR VPWR sky130_fd_sc_hd__fill_1
XFILLER_0_33_39 VPWR VGND VPWR VGND sky130_ef_sc_hd__decap_12
X_0670_ _0320_ net155 _0566_ VGND VGND VPWR VPWR _0568_ sky130_fd_sc_hd__mux2_1
X_1084_ _0461_ VGND VGND VPWR VPWR _0073_ sky130_fd_sc_hd__clkbuf_1
X_1222_ clknet_4_7_0_clk _0056_ VGND VGND VPWR VPWR u_sram.mem\[42\]\[0\] sky130_fd_sc_hd__dfxtp_1
X_1153_ _0503_ net71 _0504_ VGND VGND VPWR VPWR _0505_ sky130_fd_sc_hd__mux2_1
XFILLER_0_47_305 VGND VGND VPWR VPWR sky130_fd_sc_hd__fill_1
X_0799_ u_sram.mem\[37\]\[0\] _0173_ _0175_ u_sram.mem\[38\]\[0\] VGND VGND VPWR VPWR
+ _0247_ sky130_fd_sc_hd__a22o_1
X_0868_ _0309_ _0312_ VGND VGND VPWR VPWR _0313_ sky130_fd_sc_hd__nand2_2
XFILLER_0_30_249 VGND VGND VPWR VPWR sky130_fd_sc_hd__decap_3
X_0937_ _0350_ VGND VGND VPWR VPWR _0366_ sky130_fd_sc_hd__clkbuf_4
XFILLER_0_38_305 VGND VGND VPWR VPWR sky130_fd_sc_hd__fill_1
XFILLER_0_3_93 VPWR VGND VPWR VGND sky130_ef_sc_hd__decap_12
XFILLER_0_44_27 VGND VGND VPWR VPWR sky130_fd_sc_hd__fill_1
XFILLER_0_29_305 VGND VGND VPWR VPWR sky130_fd_sc_hd__fill_1
X_0722_ u_sram.addr_r\[3\] VGND VGND VPWR VPWR _0171_ sky130_fd_sc_hd__buf_2
XFILLER_0_8_27 VGND VGND VPWR VPWR sky130_fd_sc_hd__fill_1
X_0653_ _0308_ net152 _0557_ VGND VGND VPWR VPWR _0558_ sky130_fd_sc_hd__mux2_1
XFILLER_0_12_205 VGND VGND VPWR VPWR sky130_fd_sc_hd__fill_1
XFILLER_0_12_227 VPWR VGND VPWR VGND sky130_ef_sc_hd__decap_12
XFILLER_0_20_271 VGND VGND VPWR VPWR sky130_fd_sc_hd__fill_1
XFILLER_0_20_293 VGND VGND VPWR VPWR sky130_fd_sc_hd__decap_4
X_0584_ _0515_ VGND VGND VPWR VPWR _0106_ sky130_fd_sc_hd__clkbuf_1
XFILLER_0_47_113 VGND VGND VPWR VPWR sky130_fd_sc_hd__fill_2
X_1067_ _0391_ _0413_ VGND VGND VPWR VPWR _0451_ sky130_fd_sc_hd__or2_1
X_1136_ _0337_ _0468_ VGND VGND VPWR VPWR _0494_ sky130_fd_sc_hd__nor2_1
X_1205_ clknet_4_10_0_clk _0039_ VGND VGND VPWR VPWR u_sram.mem\[50\]\[1\] sky130_fd_sc_hd__dfxtp_1
XFILLER_0_47_124 VGND VGND VPWR VPWR sky130_fd_sc_hd__decap_4
XFILLER_0_7_243 VPWR VGND VPWR VGND sky130_ef_sc_hd__decap_12
XFILLER_0_39_27 VGND VGND VPWR VPWR sky130_fd_sc_hd__decap_8
XTAP_208 VGND VPWR sky130_fd_sc_hd__tapvpwrvgnd_1
XTAP_219 VGND VPWR sky130_fd_sc_hd__tapvpwrvgnd_1
Xhold4 u_addr_gen.done VGND VGND VPWR VPWR net20 sky130_fd_sc_hd__dlygate4sd3_1
XFILLER_0_44_149 VGND VGND VPWR VPWR sky130_fd_sc_hd__fill_1
X_0636_ _0547_ VGND VGND VPWR VPWR _0126_ sky130_fd_sc_hd__clkbuf_1
X_0705_ u_fsm.state\[2\] net2 _0149_ VGND VGND VPWR VPWR _0158_ sky130_fd_sc_hd__and3b_1
XFILLER_0_24_3 VPWR VGND VPWR VGND sky130_ef_sc_hd__decap_12
X_1119_ _0483_ VGND VGND VPWR VPWR _0086_ sky130_fd_sc_hd__clkbuf_1
XFILLER_0_35_105 VGND VGND VPWR VPWR sky130_fd_sc_hd__decap_6
XFILLER_0_43_193 VGND VGND VPWR VPWR sky130_fd_sc_hd__decap_4
XFILLER_0_9_81 VGND VGND VPWR VPWR sky130_fd_sc_hd__fill_1
XFILLER_0_28_190 VGND VGND VPWR VPWR sky130_fd_sc_hd__decap_3
XFILLER_0_26_138 VGND VGND VPWR VPWR sky130_fd_sc_hd__fill_2
XFILLER_0_1_216 VGND VGND VPWR VPWR sky130_fd_sc_hd__decap_8
XFILLER_0_1_249 VPWR VGND VPWR VGND sky130_ef_sc_hd__decap_12
XFILLER_0_5_39 VPWR VGND VPWR VGND sky130_ef_sc_hd__decap_12
XFILLER_0_9_305 VGND VGND VPWR VPWR sky130_fd_sc_hd__fill_1
XFILLER_0_15_51 VGND VGND VPWR VPWR sky130_fd_sc_hd__fill_2
XFILLER_0_40_141 VGND VGND VPWR VPWR sky130_fd_sc_hd__decap_4
XFILLER_0_0_293 VPWR VGND VPWR VGND sky130_ef_sc_hd__decap_12
X_0619_ _0537_ VGND VGND VPWR VPWR _0119_ sky130_fd_sc_hd__clkbuf_1
XFILLER_0_48_241 VGND VGND VPWR VPWR sky130_fd_sc_hd__decap_8
XFILLER_0_31_163 VGND VGND VPWR VPWR sky130_fd_sc_hd__decap_4
Xclkbuf_4_3_0_clk clknet_0_clk VGND VGND VPWR VPWR clknet_4_3_0_clk sky130_fd_sc_hd__clkbuf_8
XFILLER_0_39_252 VPWR VGND VPWR VGND sky130_ef_sc_hd__decap_12
X_0970_ _0317_ _0387_ VGND VGND VPWR VPWR _0388_ sky130_fd_sc_hd__nor2_1
XFILLER_0_26_83 VGND VGND VPWR VPWR sky130_fd_sc_hd__fill_1
XFILLER_0_9_113 VGND VGND VPWR VPWR sky130_fd_sc_hd__fill_1
XFILLER_0_6_71 VPWR VGND VPWR VGND sky130_ef_sc_hd__decap_12
XPHY_64 VGND VGND VPWR VPWR sky130_fd_sc_hd__decap_3
XPHY_20 VGND VGND VPWR VPWR sky130_fd_sc_hd__decap_3
XPHY_31 VGND VGND VPWR VPWR sky130_fd_sc_hd__decap_3
XPHY_42 VGND VGND VPWR VPWR sky130_fd_sc_hd__decap_3
XPHY_53 VGND VGND VPWR VPWR sky130_fd_sc_hd__decap_3
XFILLER_0_51_225 VPWR VGND VPWR VGND sky130_ef_sc_hd__decap_12
XPHY_97 VGND VGND VPWR VPWR sky130_fd_sc_hd__decap_3
XPHY_86 VGND VGND VPWR VPWR sky130_fd_sc_hd__decap_3
XPHY_75 VGND VGND VPWR VPWR sky130_fd_sc_hd__decap_3
XFILLER_0_36_277 VPWR VGND VPWR VGND sky130_ef_sc_hd__decap_12
XFILLER_0_47_27 VPWR VGND VPWR VGND sky130_ef_sc_hd__decap_12
XFILLER_0_2_29 VPWR VGND VPWR VGND sky130_ef_sc_hd__decap_12
XFILLER_0_42_247 VGND VGND VPWR VPWR sky130_fd_sc_hd__decap_4
X_0884_ _0310_ _0322_ _0326_ VGND VGND VPWR VPWR _0327_ sky130_fd_sc_hd__o21ai_1
XFILLER_0_6_149 VPWR VGND VPWR VGND sky130_ef_sc_hd__decap_12
XFILLER_0_12_41 VGND VGND VPWR VPWR sky130_fd_sc_hd__fill_1
XFILLER_0_12_85 VGND VGND VPWR VPWR sky130_fd_sc_hd__fill_2
X_0953_ _0314_ _0362_ _0376_ VGND VGND VPWR VPWR _0377_ sky130_fd_sc_hd__or3_2
X_1298_ clknet_4_2_0_clk _0132_ VGND VGND VPWR VPWR u_sram.mem\[4\]\[0\] sky130_fd_sc_hd__dfxtp_1
XFILLER_0_33_225 VGND VGND VPWR VPWR sky130_fd_sc_hd__decap_8
XFILLER_0_17_19 VGND VGND VPWR VPWR sky130_fd_sc_hd__fill_1
X_1221_ clknet_4_6_0_clk _0055_ VGND VGND VPWR VPWR u_sram.mem\[42\]\[1\] sky130_fd_sc_hd__dfxtp_1
X_1083_ _0424_ net73 _0460_ VGND VGND VPWR VPWR _0461_ sky130_fd_sc_hd__mux2_1
X_1152_ _0391_ _0468_ VGND VGND VPWR VPWR _0504_ sky130_fd_sc_hd__or2_1
X_0936_ _0365_ VGND VGND VPWR VPWR _0021_ sky130_fd_sc_hd__clkbuf_1
X_0867_ _0310_ _0311_ u_addr_gen.addr\[2\] VGND VGND VPWR VPWR _0312_ sky130_fd_sc_hd__and3_1
XFILLER_0_2_141 VGND VGND VPWR VPWR sky130_fd_sc_hd__fill_2
X_0798_ net29 _0167_ _0214_ _0246_ net18 VGND VGND VPWR VPWR _0005_ sky130_fd_sc_hd__o221a_1
XFILLER_0_14_291 VGND VGND VPWR VPWR sky130_fd_sc_hd__decap_3
XFILLER_0_28_29 VGND VGND VPWR VPWR sky130_fd_sc_hd__decap_6
X_0721_ u_sram.addr_r\[1\] VGND VGND VPWR VPWR _0170_ sky130_fd_sc_hd__buf_2
X_0652_ _0395_ _0520_ VGND VGND VPWR VPWR _0557_ sky130_fd_sc_hd__or2_1
XFILLER_0_12_239 VGND VGND VPWR VPWR sky130_fd_sc_hd__decap_8
X_0583_ _0492_ net38 _0513_ VGND VGND VPWR VPWR _0515_ sky130_fd_sc_hd__mux2_1
X_1204_ clknet_4_8_0_clk _0038_ VGND VGND VPWR VPWR u_sram.mem\[51\]\[0\] sky130_fd_sc_hd__dfxtp_1
X_1066_ _0450_ VGND VGND VPWR VPWR _0066_ sky130_fd_sc_hd__clkbuf_1
X_1135_ _0493_ VGND VGND VPWR VPWR _0092_ sky130_fd_sc_hd__clkbuf_1
X_0919_ _0328_ _0346_ VGND VGND VPWR VPWR _0353_ sky130_fd_sc_hd__or2_2
XFILLER_0_7_255 VPWR VGND VPWR VGND sky130_ef_sc_hd__decap_12
XFILLER_0_7_233 VGND VGND VPWR VPWR sky130_fd_sc_hd__decap_6
XFILLER_0_7_211 VGND VGND VPWR VPWR sky130_fd_sc_hd__fill_2
XFILLER_0_7_200 VGND VGND VPWR VPWR sky130_fd_sc_hd__fill_1
XTAP_209 VGND VPWR sky130_fd_sc_hd__tapvpwrvgnd_1
Xhold5 _0014_ VGND VGND VPWR VPWR net21 sky130_fd_sc_hd__dlygate4sd3_1
XFILLER_0_44_139 VGND VGND VPWR VPWR sky130_fd_sc_hd__fill_1
XFILLER_0_20_52 VGND VGND VPWR VPWR sky130_fd_sc_hd__fill_1
XFILLER_0_29_169 VGND VGND VPWR VPWR sky130_fd_sc_hd__decap_4
X_0635_ net68 _0350_ _0545_ VGND VGND VPWR VPWR _0547_ sky130_fd_sc_hd__mux2_1
X_0704_ _0157_ VGND VGND VPWR VPWR _0001_ sky130_fd_sc_hd__clkbuf_1
XFILLER_0_17_3 VPWR VGND VPWR VGND sky130_ef_sc_hd__decap_12
XFILLER_0_45_93 VGND VGND VPWR VPWR sky130_fd_sc_hd__fill_1
XFILLER_0_35_128 VPWR VGND VPWR VGND sky130_ef_sc_hd__decap_12
X_1118_ net136 _0437_ _0481_ VGND VGND VPWR VPWR _0483_ sky130_fd_sc_hd__mux2_1
X_1049_ _0440_ VGND VGND VPWR VPWR _0059_ sky130_fd_sc_hd__clkbuf_1
XFILLER_0_43_183 VGND VGND VPWR VPWR sky130_fd_sc_hd__decap_4
XFILLER_0_19_180 VGND VGND VPWR VPWR sky130_fd_sc_hd__fill_2
XFILLER_0_26_117 VGND VGND VPWR VPWR sky130_fd_sc_hd__fill_2
XFILLER_0_26_128 VGND VGND VPWR VPWR sky130_fd_sc_hd__decap_6
XFILLER_0_31_73 VGND VGND VPWR VPWR sky130_fd_sc_hd__decap_8
XFILLER_0_40_186 VGND VGND VPWR VPWR sky130_fd_sc_hd__decap_8
X_0618_ _0503_ net113 _0536_ VGND VGND VPWR VPWR _0537_ sky130_fd_sc_hd__mux2_1
XFILLER_0_48_253 VPWR VGND VPWR VGND sky130_ef_sc_hd__decap_12
XFILLER_0_6_3 VPWR VGND VPWR VGND sky130_ef_sc_hd__decap_12
XFILLER_0_36_29 VGND VGND VPWR VPWR sky130_fd_sc_hd__fill_1
XFILLER_0_39_264 VPWR VGND VPWR VGND sky130_ef_sc_hd__decap_12
XFILLER_0_45_201 VPWR VGND VPWR VGND sky130_ef_sc_hd__decap_12
XFILLER_0_42_83 VGND VGND VPWR VPWR sky130_fd_sc_hd__fill_1
XFILLER_0_13_120 VPWR VGND VPWR VGND sky130_ef_sc_hd__decap_12
XFILLER_0_13_197 VGND VGND VPWR VPWR sky130_fd_sc_hd__decap_8
XTAP_370 VGND VPWR sky130_fd_sc_hd__tapvpwrvgnd_1
XFILLER_0_6_83 VGND VGND VPWR VPWR sky130_fd_sc_hd__fill_1
XPHY_98 VGND VGND VPWR VPWR sky130_fd_sc_hd__decap_3
XPHY_87 VGND VGND VPWR VPWR sky130_fd_sc_hd__decap_3
XPHY_76 VGND VGND VPWR VPWR sky130_fd_sc_hd__decap_3
XPHY_65 VGND VGND VPWR VPWR sky130_fd_sc_hd__decap_3
XPHY_10 VGND VGND VPWR VPWR sky130_fd_sc_hd__decap_3
XPHY_21 VGND VGND VPWR VPWR sky130_fd_sc_hd__decap_3
XPHY_32 VGND VGND VPWR VPWR sky130_fd_sc_hd__decap_3
XPHY_43 VGND VGND VPWR VPWR sky130_fd_sc_hd__decap_3
XPHY_54 VGND VGND VPWR VPWR sky130_fd_sc_hd__decap_3
XFILLER_0_51_237 VPWR VGND VPWR VGND sky130_ef_sc_hd__decap_12
XFILLER_0_36_289 VPWR VGND VPWR VGND sky130_ef_sc_hd__decap_12
XFILLER_0_47_39 VPWR VGND VPWR VGND sky130_ef_sc_hd__decap_12
X_0952_ _0310_ _0311_ u_addr_gen.addr\[2\] u_addr_gen.addr\[3\] VGND VGND VPWR VPWR
+ _0376_ sky130_fd_sc_hd__or4b_2
XFILLER_0_27_278 VGND VGND VPWR VPWR sky130_fd_sc_hd__fill_2
X_0883_ _0322_ _0325_ _0000_ VGND VGND VPWR VPWR _0326_ sky130_fd_sc_hd__o21ba_2
XFILLER_0_2_301 VGND VGND VPWR VPWR sky130_fd_sc_hd__decap_4
X_1297_ clknet_4_0_0_clk _0131_ VGND VGND VPWR VPWR u_sram.mem\[4\]\[1\] sky130_fd_sc_hd__dfxtp_1
XFILLER_0_33_204 VPWR VGND VPWR VGND sky130_ef_sc_hd__decap_12
Xclkbuf_4_2_0_clk clknet_0_clk VGND VGND VPWR VPWR clknet_4_2_0_clk sky130_fd_sc_hd__clkbuf_8
XFILLER_0_41_281 VPWR VGND VPWR VGND sky130_ef_sc_hd__decap_12
XFILLER_0_5_194 VGND VGND VPWR VPWR sky130_fd_sc_hd__fill_2
X_1151_ _0307_ VGND VGND VPWR VPWR _0503_ sky130_fd_sc_hd__clkbuf_4
X_1220_ clknet_4_9_0_clk _0054_ VGND VGND VPWR VPWR u_sram.mem\[43\]\[0\] sky130_fd_sc_hd__dfxtp_1
X_1082_ _0403_ _0413_ VGND VGND VPWR VPWR _0460_ sky130_fd_sc_hd__or2_1
X_0866_ u_addr_gen.addr\[1\] VGND VGND VPWR VPWR _0311_ sky130_fd_sc_hd__clkbuf_2
X_0935_ net69 _0361_ _0364_ VGND VGND VPWR VPWR _0365_ sky130_fd_sc_hd__mux2_1
XFILLER_0_15_237 VGND VGND VPWR VPWR sky130_fd_sc_hd__fill_1
XFILLER_0_23_85 VGND VGND VPWR VPWR sky130_fd_sc_hd__fill_1
XFILLER_0_2_186 VGND VGND VPWR VPWR sky130_fd_sc_hd__decap_6
X_0797_ _0224_ _0232_ _0236_ _0245_ VGND VGND VPWR VPWR _0246_ sky130_fd_sc_hd__or4_1
XFILLER_0_23_270 VGND VGND VPWR VPWR sky130_fd_sc_hd__fill_2
XFILLER_0_47_3 VPWR VGND VPWR VGND sky130_ef_sc_hd__decap_12
XFILLER_0_3_51 VGND VGND VPWR VPWR sky130_fd_sc_hd__decap_4
XFILLER_0_44_29 VPWR VGND VPWR VGND sky130_ef_sc_hd__decap_12
XFILLER_0_8_29 VPWR VGND VPWR VGND sky130_ef_sc_hd__decap_12
X_0720_ _0168_ VGND VGND VPWR VPWR _0169_ sky130_fd_sc_hd__clkbuf_4
X_0582_ _0514_ VGND VGND VPWR VPWR _0105_ sky130_fd_sc_hd__clkbuf_1
X_0651_ _0556_ VGND VGND VPWR VPWR _0132_ sky130_fd_sc_hd__clkbuf_1
X_1134_ _0492_ net111 _0490_ VGND VGND VPWR VPWR _0493_ sky130_fd_sc_hd__mux2_1
X_1203_ clknet_4_8_0_clk _0037_ VGND VGND VPWR VPWR u_sram.mem\[51\]\[1\] sky130_fd_sc_hd__dfxtp_1
XFILLER_0_18_85 VPWR VGND VPWR VGND sky130_ef_sc_hd__decap_12
X_1065_ net117 _0437_ _0448_ VGND VGND VPWR VPWR _0450_ sky130_fd_sc_hd__mux2_1
XFILLER_0_7_223 VGND VGND VPWR VPWR sky130_fd_sc_hd__fill_1
XFILLER_0_50_83 VGND VGND VPWR VPWR sky130_fd_sc_hd__fill_1
XFILLER_0_7_267 VPWR VGND VPWR VGND sky130_ef_sc_hd__decap_12
X_0918_ _0352_ VGND VGND VPWR VPWR _0016_ sky130_fd_sc_hd__clkbuf_1
X_0849_ u_sram.mem\[60\]\[0\] _0200_ _0189_ u_sram.mem\[63\]\[0\] _0296_ VGND VGND
+ VPWR VPWR _0297_ sky130_fd_sc_hd__a221o_1
XFILLER_0_11_240 VGND VGND VPWR VPWR sky130_fd_sc_hd__decap_3
Xhold6 u_addr_gen.addr\[2\] VGND VGND VPWR VPWR net22 sky130_fd_sc_hd__dlygate4sd3_1
X_0703_ u_addr_gen.state\[1\] net158 VGND VGND VPWR VPWR _0157_ sky130_fd_sc_hd__or2_1
X_0634_ _0546_ VGND VGND VPWR VPWR _0125_ sky130_fd_sc_hd__clkbuf_1
XFILLER_0_29_40 VGND VGND VPWR VPWR sky130_fd_sc_hd__fill_1
X_1117_ _0482_ VGND VGND VPWR VPWR _0085_ sky130_fd_sc_hd__clkbuf_1
X_1048_ _0424_ net61 _0439_ VGND VGND VPWR VPWR _0440_ sky130_fd_sc_hd__mux2_1
XFILLER_0_0_41 VPWR VGND VPWR VGND sky130_ef_sc_hd__decap_12
XFILLER_0_0_85 VPWR VGND VPWR VGND sky130_ef_sc_hd__decap_12
XFILLER_0_28_170 VGND VGND VPWR VPWR sky130_fd_sc_hd__decap_8
XFILLER_0_3_281 VPWR VGND VPWR VGND sky130_ef_sc_hd__decap_12
XFILLER_0_9_50 VGND VGND VPWR VPWR sky130_fd_sc_hd__fill_1
XFILLER_0_15_64 VGND VGND VPWR VPWR sky130_fd_sc_hd__fill_1
XFILLER_0_15_86 VGND VGND VPWR VPWR sky130_fd_sc_hd__fill_1
XFILLER_0_40_110 VGND VGND VPWR VPWR sky130_fd_sc_hd__fill_2
X_0617_ _0368_ _0519_ VGND VGND VPWR VPWR _0536_ sky130_fd_sc_hd__or2_1
XFILLER_0_48_265 VPWR VGND VPWR VGND sky130_ef_sc_hd__decap_12
XFILLER_0_16_173 VPWR VGND VPWR VGND sky130_ef_sc_hd__decap_12
XFILLER_0_31_187 VGND VGND VPWR VPWR sky130_fd_sc_hd__decap_6
XFILLER_0_39_276 VGND VGND VPWR VPWR sky130_fd_sc_hd__decap_4
XFILLER_0_26_41 VPWR VGND VPWR VGND sky130_ef_sc_hd__decap_12
XFILLER_0_26_85 VPWR VGND VPWR VGND sky130_ef_sc_hd__decap_12
XFILLER_0_45_279 VGND VGND VPWR VPWR sky130_fd_sc_hd__fill_1
XFILLER_0_45_213 VGND VGND VPWR VPWR sky130_fd_sc_hd__decap_8
XFILLER_0_42_95 VGND VGND VPWR VPWR sky130_fd_sc_hd__decap_8
XFILLER_0_42_62 VGND VGND VPWR VPWR sky130_fd_sc_hd__fill_1
XFILLER_0_9_159 VGND VGND VPWR VPWR sky130_fd_sc_hd__decap_4
XFILLER_0_13_143 VPWR VGND VPWR VGND sky130_ef_sc_hd__decap_12
XTAP_371 VGND VPWR sky130_fd_sc_hd__tapvpwrvgnd_1
XTAP_360 VGND VPWR sky130_fd_sc_hd__tapvpwrvgnd_1
XPHY_99 VGND VGND VPWR VPWR sky130_fd_sc_hd__decap_3
XPHY_88 VGND VGND VPWR VPWR sky130_fd_sc_hd__decap_3
XPHY_77 VGND VGND VPWR VPWR sky130_fd_sc_hd__decap_3
XPHY_66 VGND VGND VPWR VPWR sky130_fd_sc_hd__decap_3
XPHY_11 VGND VGND VPWR VPWR sky130_fd_sc_hd__decap_3
XPHY_22 VGND VGND VPWR VPWR sky130_fd_sc_hd__decap_3
XPHY_33 VGND VGND VPWR VPWR sky130_fd_sc_hd__decap_3
XPHY_44 VGND VGND VPWR VPWR sky130_fd_sc_hd__decap_3
XPHY_55 VGND VGND VPWR VPWR sky130_fd_sc_hd__decap_3
XFILLER_0_51_249 VGND VGND VPWR VPWR sky130_fd_sc_hd__decap_3
X_0882_ _0323_ _0324_ _0151_ VGND VGND VPWR VPWR _0325_ sky130_fd_sc_hd__o21a_1
X_0951_ _0375_ VGND VGND VPWR VPWR _0026_ sky130_fd_sc_hd__clkbuf_1
X_1296_ clknet_4_2_0_clk _0130_ VGND VGND VPWR VPWR u_sram.mem\[5\]\[0\] sky130_fd_sc_hd__dfxtp_1
XFILLER_0_41_260 VPWR VGND VPWR VGND sky130_ef_sc_hd__decap_12
XFILLER_0_33_216 VGND VGND VPWR VPWR sky130_fd_sc_hd__decap_8
XFILLER_0_18_246 VGND VGND VPWR VPWR sky130_fd_sc_hd__decap_6
XFILLER_0_41_293 VPWR VGND VPWR VGND sky130_ef_sc_hd__decap_12
XTAP_190 VGND VPWR sky130_fd_sc_hd__tapvpwrvgnd_1
X_1150_ _0502_ VGND VGND VPWR VPWR _0098_ sky130_fd_sc_hd__clkbuf_1
X_1081_ _0459_ VGND VGND VPWR VPWR _0072_ sky130_fd_sc_hd__clkbuf_1
X_0865_ u_addr_gen.addr\[0\] VGND VGND VPWR VPWR _0310_ sky130_fd_sc_hd__buf_2
XFILLER_0_15_205 VGND VGND VPWR VPWR sky130_fd_sc_hd__fill_2
X_0934_ _0314_ _0363_ VGND VGND VPWR VPWR _0364_ sky130_fd_sc_hd__nor2_1
XFILLER_0_48_83 VGND VGND VPWR VPWR sky130_fd_sc_hd__fill_1
X_0796_ _0237_ _0239_ _0241_ _0244_ VGND VGND VPWR VPWR _0245_ sky130_fd_sc_hd__or4_1
X_1279_ clknet_4_0_0_clk _0113_ VGND VGND VPWR VPWR u_sram.mem\[13\]\[1\] sky130_fd_sc_hd__dfxtp_1
X_0650_ _0320_ net109 _0554_ VGND VGND VPWR VPWR _0556_ sky130_fd_sc_hd__mux2_1
X_1064_ _0449_ VGND VGND VPWR VPWR _0065_ sky130_fd_sc_hd__clkbuf_1
X_1202_ clknet_4_9_0_clk _0036_ VGND VGND VPWR VPWR u_sram.mem\[52\]\[0\] sky130_fd_sc_hd__dfxtp_1
Xclkbuf_4_1_0_clk clknet_0_clk VGND VGND VPWR VPWR clknet_4_1_0_clk sky130_fd_sc_hd__clkbuf_8
XFILLER_0_18_64 VGND VGND VPWR VPWR sky130_fd_sc_hd__decap_3
XFILLER_0_18_97 VPWR VGND VPWR VGND sky130_ef_sc_hd__decap_12
X_1133_ _0350_ VGND VGND VPWR VPWR _0492_ sky130_fd_sc_hd__buf_2
XFILLER_0_34_41 VPWR VGND VPWR VGND sky130_ef_sc_hd__decap_12
XFILLER_0_7_279 VGND VGND VPWR VPWR sky130_fd_sc_hd__fill_1
X_0848_ u_sram.mem\[53\]\[0\] _0173_ net5 u_sram.mem\[56\]\[0\] VGND VGND VPWR VPWR
+ _0296_ sky130_fd_sc_hd__a22o_1
X_0917_ _0351_ net146 _0348_ VGND VGND VPWR VPWR _0352_ sky130_fd_sc_hd__mux2_1
X_0779_ u_sram.mem\[41\]\[1\] _0168_ _0204_ VGND VGND VPWR VPWR _0228_ sky130_fd_sc_hd__and3_1
XFILLER_0_38_138 VGND VGND VPWR VPWR sky130_fd_sc_hd__fill_2
Xhold7 u_addr_gen.addr\[3\] VGND VGND VPWR VPWR net23 sky130_fd_sc_hd__dlygate4sd3_1
X_0633_ net64 _0342_ _0545_ VGND VGND VPWR VPWR _0546_ sky130_fd_sc_hd__mux2_1
X_0702_ _0156_ VGND VGND VPWR VPWR u_fsm.next_state\[1\] sky130_fd_sc_hd__clkbuf_1
XFILLER_0_20_21 VGND VGND VPWR VPWR sky130_fd_sc_hd__decap_6
XFILLER_0_45_84 VGND VGND VPWR VPWR sky130_fd_sc_hd__decap_6
XFILLER_0_45_73 VGND VGND VPWR VPWR sky130_fd_sc_hd__decap_3
X_1116_ net123 _0434_ _0481_ VGND VGND VPWR VPWR _0482_ sky130_fd_sc_hd__mux2_1
X_1047_ _0362_ _0376_ _0411_ VGND VGND VPWR VPWR _0439_ sky130_fd_sc_hd__or3_1
XFILLER_0_0_53 VGND VGND VPWR VPWR sky130_fd_sc_hd__decap_3
XFILLER_0_0_97 VPWR VGND VPWR VGND sky130_ef_sc_hd__decap_12
XFILLER_0_3_293 VPWR VGND VPWR VGND sky130_ef_sc_hd__decap_12
XFILLER_0_34_141 VGND VGND VPWR VPWR sky130_fd_sc_hd__decap_3
XFILLER_0_15_32 VGND VGND VPWR VPWR sky130_fd_sc_hd__fill_2
XFILLER_0_31_86 VPWR VGND VPWR VGND sky130_ef_sc_hd__decap_12
X_0616_ _0535_ VGND VGND VPWR VPWR _0118_ sky130_fd_sc_hd__clkbuf_1
XFILLER_0_22_3 VGND VGND VPWR VPWR sky130_fd_sc_hd__decap_8
XFILLER_0_48_277 VPWR VGND VPWR VGND sky130_ef_sc_hd__decap_12
XFILLER_0_31_111 VGND VGND VPWR VPWR sky130_fd_sc_hd__fill_1
XFILLER_0_16_130 VGND VGND VPWR VPWR sky130_fd_sc_hd__fill_1
XFILLER_0_16_141 VGND VGND VPWR VPWR sky130_fd_sc_hd__fill_2
XFILLER_0_16_185 VGND VGND VPWR VPWR sky130_fd_sc_hd__decap_3
XFILLER_0_26_53 VGND VGND VPWR VPWR sky130_fd_sc_hd__decap_6
XFILLER_0_26_75 VGND VGND VPWR VPWR sky130_fd_sc_hd__decap_8
XFILLER_0_26_97 VPWR VGND VPWR VGND sky130_ef_sc_hd__decap_12
XFILLER_0_45_225 VPWR VGND VPWR VGND sky130_ef_sc_hd__decap_12
XFILLER_0_42_85 VGND VGND VPWR VPWR sky130_fd_sc_hd__decap_6
XTAP_350 VGND VPWR sky130_fd_sc_hd__tapvpwrvgnd_1
XFILLER_0_6_41 VGND VGND VPWR VPWR sky130_fd_sc_hd__decap_8
XFILLER_0_13_155 VGND VGND VPWR VPWR sky130_fd_sc_hd__decap_6
XTAP_372 VGND VPWR sky130_fd_sc_hd__tapvpwrvgnd_1
XTAP_361 VGND VPWR sky130_fd_sc_hd__tapvpwrvgnd_1
XPHY_12 VGND VGND VPWR VPWR sky130_fd_sc_hd__decap_3
XPHY_89 VGND VGND VPWR VPWR sky130_fd_sc_hd__decap_3
XPHY_78 VGND VGND VPWR VPWR sky130_fd_sc_hd__decap_3
XFILLER_0_36_247 VGND VGND VPWR VPWR sky130_fd_sc_hd__decap_4
XPHY_67 VGND VGND VPWR VPWR sky130_fd_sc_hd__decap_3
XPHY_23 VGND VGND VPWR VPWR sky130_fd_sc_hd__decap_3
XPHY_34 VGND VGND VPWR VPWR sky130_fd_sc_hd__decap_3
XPHY_45 VGND VGND VPWR VPWR sky130_fd_sc_hd__decap_3
XPHY_56 VGND VGND VPWR VPWR sky130_fd_sc_hd__decap_3
X_0881_ u_addr_gen.addr\[4\] _0304_ VGND VGND VPWR VPWR _0324_ sky130_fd_sc_hd__nand2_1
XFILLER_0_6_119 VGND VGND VPWR VPWR sky130_fd_sc_hd__fill_1
XFILLER_0_12_77 VGND VGND VPWR VPWR sky130_fd_sc_hd__decap_4
X_0950_ net80 _0366_ _0373_ VGND VGND VPWR VPWR _0375_ sky130_fd_sc_hd__mux2_1
XFILLER_0_27_225 VGND VGND VPWR VPWR sky130_fd_sc_hd__fill_1
XFILLER_0_10_114 VGND VGND VPWR VPWR sky130_fd_sc_hd__decap_3
X_1295_ clknet_4_3_0_clk _0129_ VGND VGND VPWR VPWR u_sram.mem\[5\]\[1\] sky130_fd_sc_hd__dfxtp_1
XFILLER_0_18_269 VGND VGND VPWR VPWR sky130_fd_sc_hd__fill_1
XFILLER_0_41_272 VGND VGND VPWR VPWR sky130_fd_sc_hd__decap_8
XFILLER_0_5_185 VGND VGND VPWR VPWR sky130_fd_sc_hd__fill_1
XTAP_180 VGND VPWR sky130_fd_sc_hd__tapvpwrvgnd_1
XTAP_191 VGND VPWR sky130_fd_sc_hd__tapvpwrvgnd_1
XFILLER_0_24_206 VGND VGND VPWR VPWR sky130_fd_sc_hd__decap_8
X_1080_ _0422_ net74 _0457_ VGND VGND VPWR VPWR _0459_ sky130_fd_sc_hd__mux2_1
X_0864_ u_addr_gen.addr\[3\] VGND VGND VPWR VPWR _0309_ sky130_fd_sc_hd__buf_2
X_0933_ _0332_ _0335_ _0362_ _0309_ VGND VGND VPWR VPWR _0363_ sky130_fd_sc_hd__or4b_4
X_0795_ u_sram.mem\[4\]\[1\] net9 _0166_ _0242_ _0243_ VGND VGND VPWR VPWR _0244_
+ sky130_fd_sc_hd__a311o_1
XFILLER_0_23_250 VPWR VGND VPWR VGND sky130_ef_sc_hd__decap_12
X_1278_ clknet_4_1_0_clk _0112_ VGND VGND VPWR VPWR u_sram.mem\[14\]\[0\] sky130_fd_sc_hd__dfxtp_1
XFILLER_0_14_261 VGND VGND VPWR VPWR sky130_fd_sc_hd__fill_1
X_1201_ clknet_4_9_0_clk _0035_ VGND VGND VPWR VPWR u_sram.mem\[52\]\[1\] sky130_fd_sc_hd__dfxtp_1
XFILLER_0_20_253 VPWR VGND VPWR VGND sky130_ef_sc_hd__decap_12
XFILLER_0_20_297 VGND VGND VPWR VPWR sky130_fd_sc_hd__fill_1
X_1063_ net92 _0434_ _0448_ VGND VGND VPWR VPWR _0449_ sky130_fd_sc_hd__mux2_1
XFILLER_0_34_53 VGND VGND VPWR VPWR sky130_fd_sc_hd__decap_3
X_1132_ _0491_ VGND VGND VPWR VPWR _0091_ sky130_fd_sc_hd__clkbuf_1
XFILLER_0_50_85 VPWR VGND VPWR VGND sky130_ef_sc_hd__decap_12
XFILLER_0_50_41 VPWR VGND VPWR VGND sky130_ef_sc_hd__decap_12
XFILLER_0_47_128 VGND VGND VPWR VPWR sky130_fd_sc_hd__fill_1
XFILLER_0_34_75 VGND VGND VPWR VPWR sky130_fd_sc_hd__fill_2
X_0916_ _0350_ VGND VGND VPWR VPWR _0351_ sky130_fd_sc_hd__buf_2
X_0778_ u_sram.mem\[28\]\[1\] _0200_ _0225_ _0226_ VGND VGND VPWR VPWR _0227_ sky130_fd_sc_hd__a211o_1
XFILLER_0_11_231 VGND VGND VPWR VPWR sky130_fd_sc_hd__decap_4
X_0847_ u_sram.mem\[52\]\[0\] net9 _0194_ u_sram.mem\[55\]\[0\] _0294_ VGND VGND VPWR
+ VPWR _0295_ sky130_fd_sc_hd__a221o_1
Xhold8 u_fsm.protocol_error VGND VGND VPWR VPWR net24 sky130_fd_sc_hd__dlygate4sd3_1
XFILLER_0_37_183 VGND VGND VPWR VPWR sky130_fd_sc_hd__fill_1
X_0632_ _0337_ _0520_ VGND VGND VPWR VPWR _0545_ sky130_fd_sc_hd__nor2_1
X_0701_ _0003_ _0154_ _0155_ VGND VGND VPWR VPWR _0156_ sky130_fd_sc_hd__or3b_1
XFILLER_0_29_86 VGND VGND VPWR VPWR sky130_fd_sc_hd__fill_2
X_1115_ _0363_ _0466_ VGND VGND VPWR VPWR _0481_ sky130_fd_sc_hd__nor2_1
XFILLER_0_0_21 VGND VGND VPWR VPWR sky130_fd_sc_hd__decap_6
X_1046_ _0438_ VGND VGND VPWR VPWR _0058_ sky130_fd_sc_hd__clkbuf_1
XFILLER_0_3_261 VPWR VGND VPWR VGND sky130_ef_sc_hd__decap_12
XFILLER_0_19_172 VGND VGND VPWR VPWR sky130_fd_sc_hd__decap_8
XFILLER_0_26_109 VGND VGND VPWR VPWR sky130_fd_sc_hd__decap_8
Xclkbuf_4_0_0_clk clknet_0_clk VGND VGND VPWR VPWR clknet_4_0_0_clk sky130_fd_sc_hd__clkbuf_8
XFILLER_0_19_194 VGND VGND VPWR VPWR sky130_fd_sc_hd__fill_1
XFILLER_0_31_98 VGND VGND VPWR VPWR sky130_fd_sc_hd__fill_1
XFILLER_0_25_120 VGND VGND VPWR VPWR sky130_fd_sc_hd__decap_4
XFILLER_0_0_253 VGND VGND VPWR VPWR sky130_fd_sc_hd__fill_2
X_0615_ net63 _0350_ _0533_ VGND VGND VPWR VPWR _0535_ sky130_fd_sc_hd__mux2_1
XFILLER_0_15_3 VGND VGND VPWR VPWR sky130_fd_sc_hd__decap_4
XFILLER_0_48_289 VPWR VGND VPWR VGND sky130_ef_sc_hd__decap_12
X_1029_ _0427_ VGND VGND VPWR VPWR _0052_ sky130_fd_sc_hd__clkbuf_1
XFILLER_0_31_167 VGND VGND VPWR VPWR sky130_fd_sc_hd__fill_1
XFILLER_0_39_223 VGND VGND VPWR VPWR sky130_fd_sc_hd__fill_1
XFILLER_0_45_237 VPWR VGND VPWR VGND sky130_ef_sc_hd__decap_12
XFILLER_0_42_75 VGND VGND VPWR VPWR sky130_fd_sc_hd__decap_8
XFILLER_0_13_101 VGND VGND VPWR VPWR sky130_fd_sc_hd__decap_8
XFILLER_0_13_167 VGND VGND VPWR VPWR sky130_fd_sc_hd__fill_1
XTAP_373 VGND VPWR sky130_fd_sc_hd__tapvpwrvgnd_1
XTAP_362 VGND VPWR sky130_fd_sc_hd__tapvpwrvgnd_1
XTAP_351 VGND VPWR sky130_fd_sc_hd__tapvpwrvgnd_1
XTAP_340 VGND VPWR sky130_fd_sc_hd__tapvpwrvgnd_1
XPHY_13 VGND VGND VPWR VPWR sky130_fd_sc_hd__decap_3
XPHY_24 VGND VGND VPWR VPWR sky130_fd_sc_hd__decap_3
XPHY_35 VGND VGND VPWR VPWR sky130_fd_sc_hd__decap_3
XPHY_46 VGND VGND VPWR VPWR sky130_fd_sc_hd__decap_3
XPHY_79 VGND VGND VPWR VPWR sky130_fd_sc_hd__decap_3
XPHY_68 VGND VGND VPWR VPWR sky130_fd_sc_hd__decap_3
XFILLER_0_8_194 VGND VGND VPWR VPWR sky130_fd_sc_hd__fill_2
XPHY_57 VGND VGND VPWR VPWR sky130_fd_sc_hd__decap_3
XFILLER_0_4_3 VPWR VGND VPWR VGND sky130_ef_sc_hd__decap_12
XFILLER_0_50_251 VGND VGND VPWR VPWR sky130_fd_sc_hd__fill_1
XFILLER_0_35_281 VPWR VGND VPWR VGND sky130_ef_sc_hd__decap_12
X_0880_ u_addr_gen.addr\[5\] VGND VGND VPWR VPWR _0323_ sky130_fd_sc_hd__inv_2
XFILLER_0_10_126 VGND VGND VPWR VPWR sky130_fd_sc_hd__fill_2
X_1294_ clknet_4_2_0_clk _0128_ VGND VGND VPWR VPWR u_sram.mem\[6\]\[0\] sky130_fd_sc_hd__dfxtp_1
XTAP_170 VGND VPWR sky130_fd_sc_hd__tapvpwrvgnd_1
XTAP_181 VGND VPWR sky130_fd_sc_hd__tapvpwrvgnd_1
XTAP_192 VGND VPWR sky130_fd_sc_hd__tapvpwrvgnd_1
X_0932_ _0315_ VGND VGND VPWR VPWR _0362_ sky130_fd_sc_hd__buf_2
X_0863_ _0307_ VGND VGND VPWR VPWR _0308_ sky130_fd_sc_hd__buf_2
X_0794_ u_sram.mem\[61\]\[1\] _0207_ _0223_ VGND VGND VPWR VPWR _0243_ sky130_fd_sc_hd__and3_1
XFILLER_0_23_262 VGND VGND VPWR VPWR sky130_fd_sc_hd__decap_8
XFILLER_0_48_41 VPWR VGND VPWR VGND sky130_ef_sc_hd__decap_12
X_1277_ clknet_4_1_0_clk _0111_ VGND VGND VPWR VPWR u_sram.mem\[14\]\[1\] sky130_fd_sc_hd__dfxtp_1
X_1200_ clknet_4_2_0_clk _0034_ VGND VGND VPWR VPWR u_sram.mem\[53\]\[0\] sky130_fd_sc_hd__dfxtp_1
XFILLER_0_20_265 VGND VGND VPWR VPWR sky130_fd_sc_hd__decap_6
X_1062_ _0387_ _0413_ VGND VGND VPWR VPWR _0448_ sky130_fd_sc_hd__nor2_1
X_1131_ _0424_ net59 _0490_ VGND VGND VPWR VPWR _0491_ sky130_fd_sc_hd__mux2_1
XFILLER_0_50_97 VGND VGND VPWR VPWR sky130_fd_sc_hd__decap_6
XFILLER_0_50_53 VPWR VGND VPWR VGND sky130_ef_sc_hd__decap_12
X_0915_ u_pattern_gen.state_r\[0\] VGND VGND VPWR VPWR _0350_ sky130_fd_sc_hd__clkbuf_4
X_0777_ u_sram.mem\[26\]\[1\] _0199_ _0210_ u_sram.mem\[27\]\[1\] VGND VGND VPWR VPWR
+ _0226_ sky130_fd_sc_hd__a22o_1
X_0846_ u_sram.mem\[54\]\[0\] _0175_ _0207_ u_sram.mem\[61\]\[0\] VGND VGND VPWR VPWR
+ _0294_ sky130_fd_sc_hd__a22o_1
XFILLER_0_45_3 VPWR VGND VPWR VGND sky130_ef_sc_hd__decap_12
X_1329_ clknet_4_10_0_clk _0003_ net12 VGND VGND VPWR VPWR net3 sky130_fd_sc_hd__dfrtp_1
Xhold9 _0145_ VGND VGND VPWR VPWR net25 sky130_fd_sc_hd__dlygate4sd3_1
X_0700_ u_fsm.state\[2\] u_fsm.state\[1\] u_fsm.state\[0\] VGND VGND VPWR VPWR _0155_
+ sky130_fd_sc_hd__or3b_2
XFILLER_0_40_305 VGND VGND VPWR VPWR sky130_fd_sc_hd__fill_1
X_0631_ _0544_ VGND VGND VPWR VPWR _0124_ sky130_fd_sc_hd__clkbuf_1
X_1114_ _0480_ VGND VGND VPWR VPWR _0084_ sky130_fd_sc_hd__clkbuf_1
XFILLER_0_29_54 VGND VGND VPWR VPWR sky130_fd_sc_hd__fill_2
XFILLER_0_29_65 VGND VGND VPWR VPWR sky130_fd_sc_hd__fill_2
X_1045_ net33 _0437_ _0435_ VGND VGND VPWR VPWR _0438_ sky130_fd_sc_hd__mux2_1
XFILLER_0_43_187 VGND VGND VPWR VPWR sky130_fd_sc_hd__fill_1
XFILLER_0_43_165 VGND VGND VPWR VPWR sky130_fd_sc_hd__decap_3
X_0829_ u_sram.mem\[31\]\[0\] _0189_ _0275_ _0276_ VGND VGND VPWR VPWR _0277_ sky130_fd_sc_hd__a211o_1
XFILLER_0_31_305 VGND VGND VPWR VPWR sky130_fd_sc_hd__fill_1
XFILLER_0_9_97 VPWR VGND VPWR VGND sky130_ef_sc_hd__decap_12
XFILLER_0_28_162 VGND VGND VPWR VPWR sky130_fd_sc_hd__decap_4
XFILLER_0_28_184 VGND VGND VPWR VPWR sky130_fd_sc_hd__fill_2
XFILLER_0_3_273 VGND VGND VPWR VPWR sky130_fd_sc_hd__decap_6
XFILLER_0_19_151 VGND VGND VPWR VPWR sky130_fd_sc_hd__decap_6
XFILLER_0_19_162 VGND VGND VPWR VPWR sky130_fd_sc_hd__decap_6
XFILLER_0_22_305 VGND VGND VPWR VPWR sky130_fd_sc_hd__fill_1
XFILLER_0_13_305 VGND VGND VPWR VPWR sky130_fd_sc_hd__fill_1
X_0614_ _0534_ VGND VGND VPWR VPWR _0117_ sky130_fd_sc_hd__clkbuf_1
XFILLER_0_0_221 VGND VGND VPWR VPWR sky130_fd_sc_hd__decap_3
X_1028_ _0422_ net98 _0425_ VGND VGND VPWR VPWR _0427_ sky130_fd_sc_hd__mux2_1
XFILLER_0_22_168 VGND VGND VPWR VPWR sky130_fd_sc_hd__fill_2
XFILLER_0_45_249 VPWR VGND VPWR VGND sky130_ef_sc_hd__decap_12
XFILLER_0_13_135 VGND VGND VPWR VPWR sky130_fd_sc_hd__fill_2
XTAP_363 VGND VPWR sky130_fd_sc_hd__tapvpwrvgnd_1
XTAP_352 VGND VPWR sky130_fd_sc_hd__tapvpwrvgnd_1
XTAP_341 VGND VPWR sky130_fd_sc_hd__tapvpwrvgnd_1
XTAP_330 VGND VPWR sky130_fd_sc_hd__tapvpwrvgnd_1
XPHY_69 VGND VGND VPWR VPWR sky130_fd_sc_hd__decap_3
XPHY_14 VGND VGND VPWR VPWR sky130_fd_sc_hd__decap_3
XPHY_25 VGND VGND VPWR VPWR sky130_fd_sc_hd__decap_3
XPHY_36 VGND VGND VPWR VPWR sky130_fd_sc_hd__decap_3
XPHY_47 VGND VGND VPWR VPWR sky130_fd_sc_hd__decap_3
XPHY_58 VGND VGND VPWR VPWR sky130_fd_sc_hd__decap_3
XFILLER_0_35_293 VPWR VGND VPWR VGND sky130_ef_sc_hd__decap_12
XFILLER_0_2_305 VGND VGND VPWR VPWR sky130_fd_sc_hd__fill_1
X_1293_ clknet_4_2_0_clk _0127_ VGND VGND VPWR VPWR u_sram.mem\[6\]\[1\] sky130_fd_sc_hd__dfxtp_1
XTAP_160 VGND VPWR sky130_fd_sc_hd__tapvpwrvgnd_1
XTAP_171 VGND VPWR sky130_fd_sc_hd__tapvpwrvgnd_1
XTAP_182 VGND VPWR sky130_fd_sc_hd__tapvpwrvgnd_1
XTAP_193 VGND VPWR sky130_fd_sc_hd__tapvpwrvgnd_1
X_0931_ _0342_ VGND VGND VPWR VPWR _0361_ sky130_fd_sc_hd__buf_2
X_0862_ u_pattern_gen.state_r\[0\] u_pattern_gen.state_r\[1\] VGND VGND VPWR VPWR
+ _0307_ sky130_fd_sc_hd__xor2_2
XFILLER_0_23_45 VGND VGND VPWR VPWR sky130_fd_sc_hd__decap_8
X_0793_ net10 _0166_ VGND VGND VPWR VPWR _0242_ sky130_fd_sc_hd__and2_1
XFILLER_0_48_53 VPWR VGND VPWR VGND sky130_ef_sc_hd__decap_12
XFILLER_0_3_55 VGND VGND VPWR VPWR sky130_fd_sc_hd__fill_1
X_1276_ clknet_4_0_0_clk _0110_ VGND VGND VPWR VPWR u_sram.mem\[15\]\[0\] sky130_fd_sc_hd__dfxtp_1
XFILLER_0_49_193 VPWR VGND VPWR VGND sky130_ef_sc_hd__decap_12
XFILLER_0_20_244 VGND VGND VPWR VPWR sky130_fd_sc_hd__decap_8
X_1130_ _0362_ _0376_ _0466_ VGND VGND VPWR VPWR _0490_ sky130_fd_sc_hd__or3_1
XFILLER_0_18_45 VGND VGND VPWR VPWR sky130_fd_sc_hd__fill_1
X_1061_ _0447_ VGND VGND VPWR VPWR _0064_ sky130_fd_sc_hd__clkbuf_1
XFILLER_0_28_300 VGND VGND VPWR VPWR sky130_fd_sc_hd__decap_6
XFILLER_0_50_65 VPWR VGND VPWR VGND sky130_ef_sc_hd__decap_12
X_0914_ _0349_ VGND VGND VPWR VPWR _0015_ sky130_fd_sc_hd__clkbuf_1
X_0845_ u_sram.mem\[49\]\[0\] net11 net7 u_sram.mem\[50\]\[0\] _0292_ VGND VGND VPWR
+ VPWR _0293_ sky130_fd_sc_hd__a221o_1
X_0776_ u_sram.mem\[29\]\[1\] _0207_ _0189_ u_sram.mem\[31\]\[1\] VGND VGND VPWR VPWR
+ _0225_ sky130_fd_sc_hd__a22o_1
XFILLER_0_38_3 VPWR VGND VPWR VGND sky130_ef_sc_hd__decap_12
X_1328_ clknet_4_10_0_clk _0147_ net12 VGND VGND VPWR VPWR u_comparator.pass_fail
+ sky130_fd_sc_hd__dfstp_1
X_1259_ clknet_4_4_0_clk _0093_ VGND VGND VPWR VPWR u_sram.mem\[23\]\[1\] sky130_fd_sc_hd__dfxtp_1
XFILLER_0_37_141 VGND VGND VPWR VPWR sky130_fd_sc_hd__fill_1
X_0630_ _0320_ net40 _0542_ VGND VGND VPWR VPWR _0544_ sky130_fd_sc_hd__mux2_1
XFILLER_0_29_44 VGND VGND VPWR VPWR sky130_fd_sc_hd__fill_1
X_1113_ _0422_ net83 _0478_ VGND VGND VPWR VPWR _0480_ sky130_fd_sc_hd__mux2_1
X_1044_ _0350_ VGND VGND VPWR VPWR _0437_ sky130_fd_sc_hd__clkbuf_4
XFILLER_0_43_144 VGND VGND VPWR VPWR sky130_fd_sc_hd__fill_2
X_0828_ u_sram.mem\[26\]\[0\] _0199_ _0210_ u_sram.mem\[27\]\[0\] VGND VGND VPWR VPWR
+ _0276_ sky130_fd_sc_hd__a22o_1
XFILLER_0_9_54 VGND VGND VPWR VPWR sky130_fd_sc_hd__fill_2
X_0759_ u_sram.mem\[13\]\[1\] _0207_ _0189_ u_sram.mem\[15\]\[1\] VGND VGND VPWR VPWR
+ _0208_ sky130_fd_sc_hd__a22o_1
XFILLER_0_15_68 VGND VGND VPWR VPWR sky130_fd_sc_hd__fill_1
XFILLER_0_40_158 VGND VGND VPWR VPWR sky130_fd_sc_hd__fill_2
X_0613_ net65 _0342_ _0533_ VGND VGND VPWR VPWR _0534_ sky130_fd_sc_hd__mux2_1
XFILLER_0_25_111 VGND VGND VPWR VPWR sky130_fd_sc_hd__fill_1
XFILLER_0_25_188 VPWR VGND VPWR VGND sky130_ef_sc_hd__decap_12
X_1027_ _0426_ VGND VGND VPWR VPWR _0051_ sky130_fd_sc_hd__clkbuf_1
Xhold90 u_sram.mem\[2\]\[0\] VGND VGND VPWR VPWR net106 sky130_fd_sc_hd__dlygate4sd3_1
XFILLER_0_13_169 VGND VGND VPWR VPWR sky130_fd_sc_hd__fill_1
XTAP_364 VGND VPWR sky130_fd_sc_hd__tapvpwrvgnd_1
XTAP_353 VGND VPWR sky130_fd_sc_hd__tapvpwrvgnd_1
XTAP_342 VGND VPWR sky130_fd_sc_hd__tapvpwrvgnd_1
XTAP_331 VGND VPWR sky130_fd_sc_hd__tapvpwrvgnd_1
XTAP_320 VGND VPWR sky130_fd_sc_hd__tapvpwrvgnd_1
XFILLER_0_20_3 VPWR VGND VPWR VGND sky130_ef_sc_hd__decap_12
XFILLER_0_36_217 VGND VGND VPWR VPWR sky130_fd_sc_hd__decap_3
XPHY_15 VGND VGND VPWR VPWR sky130_fd_sc_hd__decap_3
XPHY_26 VGND VGND VPWR VPWR sky130_fd_sc_hd__decap_3
XPHY_37 VGND VGND VPWR VPWR sky130_fd_sc_hd__decap_3
XPHY_48 VGND VGND VPWR VPWR sky130_fd_sc_hd__decap_3
XPHY_59 VGND VGND VPWR VPWR sky130_fd_sc_hd__decap_3
XFILLER_0_51_209 VPWR VGND VPWR VGND sky130_ef_sc_hd__decap_12
XFILLER_0_50_253 VPWR VGND VPWR VGND sky130_ef_sc_hd__decap_12
XFILLER_0_35_261 VPWR VGND VPWR VGND sky130_ef_sc_hd__decap_12
XFILLER_0_37_55 VGND VGND VPWR VPWR sky130_fd_sc_hd__fill_1
X_1292_ clknet_4_0_0_clk _0126_ VGND VGND VPWR VPWR u_sram.mem\[7\]\[0\] sky130_fd_sc_hd__dfxtp_1
XFILLER_0_18_206 VPWR VGND VPWR VGND sky130_ef_sc_hd__decap_12
XFILLER_0_41_220 VGND VGND VPWR VPWR sky130_fd_sc_hd__decap_4
XFILLER_0_5_111 VGND VGND VPWR VPWR sky130_fd_sc_hd__fill_1
XTAP_150 VGND VPWR sky130_fd_sc_hd__tapvpwrvgnd_1
XTAP_161 VGND VPWR sky130_fd_sc_hd__tapvpwrvgnd_1
XTAP_172 VGND VPWR sky130_fd_sc_hd__tapvpwrvgnd_1
XTAP_183 VGND VPWR sky130_fd_sc_hd__tapvpwrvgnd_1
XTAP_194 VGND VPWR sky130_fd_sc_hd__tapvpwrvgnd_1
X_0930_ _0360_ VGND VGND VPWR VPWR _0020_ sky130_fd_sc_hd__clkbuf_1
X_0792_ u_sram.mem\[25\]\[1\] _0204_ _0185_ _0240_ VGND VGND VPWR VPWR _0241_ sky130_fd_sc_hd__a31o_1
X_0861_ _0306_ VGND VGND VPWR VPWR _0000_ sky130_fd_sc_hd__buf_1
XFILLER_0_48_65 VPWR VGND VPWR VGND sky130_ef_sc_hd__decap_12
X_1275_ clknet_4_0_0_clk _0109_ VGND VGND VPWR VPWR u_sram.mem\[15\]\[1\] sky130_fd_sc_hd__dfxtp_1
XFILLER_0_46_301 VGND VGND VPWR VPWR sky130_fd_sc_hd__decap_4
XFILLER_0_14_253 VGND VGND VPWR VPWR sky130_fd_sc_hd__decap_8
XFILLER_0_20_289 VGND VGND VPWR VPWR sky130_fd_sc_hd__fill_1
X_1060_ net112 _0437_ _0445_ VGND VGND VPWR VPWR _0447_ sky130_fd_sc_hd__mux2_1
XFILLER_0_34_67 VGND VGND VPWR VPWR sky130_fd_sc_hd__decap_8
XFILLER_0_7_239 VGND VGND VPWR VPWR sky130_fd_sc_hd__fill_1
XFILLER_0_50_77 VGND VGND VPWR VPWR sky130_fd_sc_hd__decap_6
X_0844_ u_sram.mem\[48\]\[0\] net10 _0203_ u_sram.mem\[62\]\[0\] VGND VGND VPWR VPWR
+ _0292_ sky130_fd_sc_hd__a22o_1
X_0913_ _0343_ net144 _0348_ VGND VGND VPWR VPWR _0349_ sky130_fd_sc_hd__mux2_1
X_0775_ _0216_ _0218_ _0222_ _0223_ VGND VGND VPWR VPWR _0224_ sky130_fd_sc_hd__o31a_1
X_1258_ clknet_4_6_0_clk _0092_ VGND VGND VPWR VPWR u_sram.mem\[24\]\[0\] sky130_fd_sc_hd__dfxtp_1
X_1189_ clknet_4_3_0_clk _0023_ VGND VGND VPWR VPWR u_sram.mem\[58\]\[1\] sky130_fd_sc_hd__dfxtp_1
X_1327_ clknet_4_14_0_clk _0002_ net13 VGND VGND VPWR VPWR u_addr_gen.start sky130_fd_sc_hd__dfrtp_1
XFILLER_0_46_153 VGND VGND VPWR VPWR sky130_fd_sc_hd__fill_1
XFILLER_0_29_23 VGND VGND VPWR VPWR sky130_fd_sc_hd__fill_2
XFILLER_0_29_34 VGND VGND VPWR VPWR sky130_fd_sc_hd__decap_6
X_1112_ _0479_ VGND VGND VPWR VPWR _0083_ sky130_fd_sc_hd__clkbuf_1
X_1043_ _0436_ VGND VGND VPWR VPWR _0057_ sky130_fd_sc_hd__clkbuf_1
XFILLER_0_0_57 VPWR VGND VPWR VGND sky130_ef_sc_hd__decap_12
XFILLER_0_16_304 VGND VGND VPWR VPWR sky130_fd_sc_hd__fill_2
XFILLER_0_28_120 VPWR VGND VPWR VGND sky130_ef_sc_hd__decap_12
XFILLER_0_28_197 VGND VGND VPWR VPWR sky130_fd_sc_hd__fill_2
X_0827_ u_sram.mem\[28\]\[0\] _0200_ _0207_ u_sram.mem\[29\]\[0\] VGND VGND VPWR VPWR
+ _0275_ sky130_fd_sc_hd__a22o_1
X_0758_ u_sram.addr_r\[1\] u_sram.addr_r\[3\] u_sram.addr_r\[2\] u_sram.addr_r\[0\]
+ VGND VGND VPWR VPWR _0207_ sky130_fd_sc_hd__and4b_4
XFILLER_0_50_3 VPWR VGND VPWR VGND sky130_ef_sc_hd__decap_12
X_0689_ u_comparator.pass_fail _0579_ u_comparator.enable VGND VGND VPWR VPWR _0580_
+ sky130_fd_sc_hd__mux2_1
X_0612_ _0363_ _0519_ VGND VGND VPWR VPWR _0533_ sky130_fd_sc_hd__nor2_1
XFILLER_0_25_167 VGND VGND VPWR VPWR sky130_fd_sc_hd__fill_1
XFILLER_0_0_278 VGND VGND VPWR VPWR sky130_fd_sc_hd__fill_2
X_1026_ _0424_ net82 _0425_ VGND VGND VPWR VPWR _0426_ sky130_fd_sc_hd__mux2_1
XFILLER_0_16_112 VPWR VGND VPWR VGND sky130_ef_sc_hd__decap_12
XFILLER_0_47_281 VPWR VGND VPWR VGND sky130_ef_sc_hd__decap_12
Xhold91 u_sram.mem\[34\]\[1\] VGND VGND VPWR VPWR net107 sky130_fd_sc_hd__dlygate4sd3_1
XFILLER_0_9_109 VGND VGND VPWR VPWR sky130_fd_sc_hd__decap_3
Xhold80 u_sram.mem\[13\]\[0\] VGND VGND VPWR VPWR net96 sky130_fd_sc_hd__dlygate4sd3_1
XTAP_332 VGND VPWR sky130_fd_sc_hd__tapvpwrvgnd_1
XTAP_321 VGND VPWR sky130_fd_sc_hd__tapvpwrvgnd_1
XTAP_310 VGND VPWR sky130_fd_sc_hd__tapvpwrvgnd_1
XTAP_365 VGND VPWR sky130_fd_sc_hd__tapvpwrvgnd_1
XTAP_354 VGND VPWR sky130_fd_sc_hd__tapvpwrvgnd_1
XTAP_343 VGND VPWR sky130_fd_sc_hd__tapvpwrvgnd_1
XFILLER_0_13_3 VPWR VGND VPWR VGND sky130_ef_sc_hd__decap_12
X_1009_ net119 _0361_ _0414_ VGND VGND VPWR VPWR _0415_ sky130_fd_sc_hd__mux2_1
XFILLER_0_8_153 VGND VGND VPWR VPWR sky130_fd_sc_hd__fill_2
XPHY_16 VGND VGND VPWR VPWR sky130_fd_sc_hd__decap_3
XPHY_27 VGND VGND VPWR VPWR sky130_fd_sc_hd__decap_3
XPHY_38 VGND VGND VPWR VPWR sky130_fd_sc_hd__decap_3
XPHY_49 VGND VGND VPWR VPWR sky130_fd_sc_hd__decap_3
XFILLER_0_29_281 VPWR VGND VPWR VGND sky130_ef_sc_hd__decap_12
XFILLER_0_44_251 VGND VGND VPWR VPWR sky130_fd_sc_hd__fill_1
XFILLER_0_35_273 VGND VGND VPWR VPWR sky130_fd_sc_hd__decap_6
XFILLER_0_12_15 VPWR VGND VPWR VGND sky130_ef_sc_hd__decap_12
XFILLER_0_12_59 VGND VGND VPWR VPWR sky130_fd_sc_hd__decap_6
XFILLER_0_50_265 VPWR VGND VPWR VGND sky130_ef_sc_hd__decap_12
XFILLER_0_50_221 VPWR VGND VPWR VGND sky130_ef_sc_hd__decap_12
XFILLER_0_37_78 VPWR VGND VPWR VGND sky130_ef_sc_hd__decap_12
X_1291_ clknet_4_0_0_clk _0125_ VGND VGND VPWR VPWR u_sram.mem\[7\]\[1\] sky130_fd_sc_hd__dfxtp_1
XFILLER_0_18_218 VGND VGND VPWR VPWR sky130_fd_sc_hd__fill_1
XTAP_151 VGND VPWR sky130_fd_sc_hd__tapvpwrvgnd_1
XTAP_140 VGND VPWR sky130_fd_sc_hd__tapvpwrvgnd_1
XTAP_162 VGND VPWR sky130_fd_sc_hd__tapvpwrvgnd_1
XTAP_173 VGND VPWR sky130_fd_sc_hd__tapvpwrvgnd_1
XTAP_184 VGND VPWR sky130_fd_sc_hd__tapvpwrvgnd_1
XTAP_195 VGND VPWR sky130_fd_sc_hd__tapvpwrvgnd_1
XFILLER_0_32_276 VPWR VGND VPWR VGND sky130_ef_sc_hd__decap_12
XFILLER_0_2_3 VPWR VGND VPWR VGND sky130_ef_sc_hd__decap_12
X_0791_ u_sram.mem\[8\]\[1\] _0166_ net5 VGND VGND VPWR VPWR _0240_ sky130_fd_sc_hd__and3_1
XFILLER_0_23_221 VGND VGND VPWR VPWR sky130_fd_sc_hd__decap_3
X_0860_ _0302_ u_addr_gen.state\[0\] VGND VGND VPWR VPWR _0306_ sky130_fd_sc_hd__and2_1
XFILLER_0_48_88 VGND VGND VPWR VPWR sky130_fd_sc_hd__fill_1
XFILLER_0_48_77 VGND VGND VPWR VPWR sky130_fd_sc_hd__decap_6
XFILLER_0_3_57 VPWR VGND VPWR VGND sky130_ef_sc_hd__decap_12
X_1274_ clknet_4_15_0_clk _0108_ VGND VGND VPWR VPWR u_sram.mem\[16\]\[0\] sky130_fd_sc_hd__dfxtp_1
XFILLER_0_13_91 VGND VGND VPWR VPWR sky130_fd_sc_hd__fill_1
X_0989_ _0343_ net137 _0400_ VGND VGND VPWR VPWR _0401_ sky130_fd_sc_hd__mux2_1
XFILLER_0_14_221 VGND VGND VPWR VPWR sky130_fd_sc_hd__decap_4
XFILLER_0_14_265 VGND VGND VPWR VPWR sky130_fd_sc_hd__decap_3
XFILLER_0_1_181 VPWR VGND VPWR VGND sky130_ef_sc_hd__decap_12
XFILLER_0_49_140 VPWR VGND VPWR VGND sky130_ef_sc_hd__decap_12
XFILLER_0_43_305 VGND VGND VPWR VPWR sky130_fd_sc_hd__fill_1
X_0912_ _0314_ _0347_ VGND VGND VPWR VPWR _0348_ sky130_fd_sc_hd__or2_1
XFILLER_0_11_235 VGND VGND VPWR VPWR sky130_fd_sc_hd__fill_1
X_0843_ _0285_ _0287_ _0290_ _0166_ VGND VGND VPWR VPWR _0291_ sky130_fd_sc_hd__o31a_1
X_0774_ u_sram.addr_r\[5\] u_sram.addr_r\[4\] VGND VGND VPWR VPWR _0223_ sky130_fd_sc_hd__and2_2
XFILLER_0_11_279 VGND VGND VPWR VPWR sky130_fd_sc_hd__fill_1
X_1326_ clknet_4_11_0_clk u_fsm.next_state\[2\] net13 VGND VGND VPWR VPWR u_fsm.state\[2\]
+ sky130_fd_sc_hd__dfrtp_4
X_1257_ clknet_4_6_0_clk _0091_ VGND VGND VPWR VPWR u_sram.mem\[24\]\[1\] sky130_fd_sc_hd__dfxtp_1
X_1188_ clknet_4_8_0_clk _0022_ VGND VGND VPWR VPWR u_sram.mem\[59\]\[0\] sky130_fd_sc_hd__dfxtp_1
XFILLER_0_46_110 VGND VGND VPWR VPWR sky130_fd_sc_hd__decap_4
XFILLER_0_34_305 VGND VGND VPWR VPWR sky130_fd_sc_hd__fill_1
XFILLER_0_6_251 VGND VGND VPWR VPWR sky130_fd_sc_hd__fill_1
XFILLER_0_25_305 VGND VGND VPWR VPWR sky130_fd_sc_hd__fill_1
XFILLER_0_20_15 VGND VGND VPWR VPWR sky130_fd_sc_hd__decap_3
XFILLER_0_20_48 VGND VGND VPWR VPWR sky130_fd_sc_hd__decap_4
Xmax_cap1 _0164_ VGND VGND VPWR VPWR net162 sky130_fd_sc_hd__buf_1
X_1111_ _0424_ net94 _0478_ VGND VGND VPWR VPWR _0479_ sky130_fd_sc_hd__mux2_1
X_1042_ net36 _0434_ _0435_ VGND VGND VPWR VPWR _0436_ sky130_fd_sc_hd__mux2_1
XFILLER_0_43_124 VPWR VGND VPWR VGND sky130_ef_sc_hd__decap_12
XFILLER_0_43_113 VGND VGND VPWR VPWR sky130_fd_sc_hd__decap_8
XFILLER_0_43_102 VGND VGND VPWR VPWR sky130_fd_sc_hd__fill_1
XFILLER_0_0_69 VPWR VGND VPWR VGND sky130_ef_sc_hd__decap_12
XFILLER_0_28_132 VGND VGND VPWR VPWR sky130_fd_sc_hd__fill_1
X_0688_ _0576_ _0342_ _0578_ VGND VGND VPWR VPWR _0579_ sky130_fd_sc_hd__a21oi_1
X_0757_ u_sram.mem\[10\]\[1\] _0199_ _0203_ u_sram.mem\[14\]\[1\] _0205_ VGND VGND
+ VPWR VPWR _0206_ sky130_fd_sc_hd__a221o_1
X_0826_ _0266_ _0271_ _0272_ _0273_ VGND VGND VPWR VPWR _0274_ sky130_fd_sc_hd__or4_1
XFILLER_0_43_3 VPWR VGND VPWR VGND sky130_ef_sc_hd__decap_12
X_1309_ clknet_4_15_0_clk net17 net15 VGND VGND VPWR VPWR u_sram.addr_r\[1\] sky130_fd_sc_hd__dfrtp_4
Xclkbuf_4_15_0_clk clknet_0_clk VGND VGND VPWR VPWR clknet_4_15_0_clk sky130_fd_sc_hd__clkbuf_8
X_0611_ _0532_ VGND VGND VPWR VPWR _0116_ sky130_fd_sc_hd__clkbuf_1
XFILLER_0_48_249 VGND VGND VPWR VPWR sky130_fd_sc_hd__decap_3
XFILLER_0_48_205 VPWR VGND VPWR VGND sky130_ef_sc_hd__decap_12
X_1025_ _0357_ _0411_ VGND VGND VPWR VPWR _0425_ sky130_fd_sc_hd__or2_1
X_0809_ u_sram.mem\[39\]\[0\] _0169_ _0194_ _0256_ VGND VGND VPWR VPWR _0257_ sky130_fd_sc_hd__a31o_1
XFILLER_0_16_124 VGND VGND VPWR VPWR sky130_fd_sc_hd__decap_6
XFILLER_0_47_293 VPWR VGND VPWR VGND sky130_ef_sc_hd__decap_12
Xhold81 u_sram.mem\[15\]\[1\] VGND VGND VPWR VPWR net97 sky130_fd_sc_hd__dlygate4sd3_1
Xhold92 u_sram.mem\[9\]\[0\] VGND VGND VPWR VPWR net108 sky130_fd_sc_hd__dlygate4sd3_1
Xhold70 u_sram.mem\[9\]\[1\] VGND VGND VPWR VPWR net86 sky130_fd_sc_hd__dlygate4sd3_1
XFILLER_0_30_193 VGND VGND VPWR VPWR sky130_fd_sc_hd__decap_3
XFILLER_0_5_305 VGND VGND VPWR VPWR sky130_fd_sc_hd__fill_1
XTAP_366 VGND VPWR sky130_fd_sc_hd__tapvpwrvgnd_1
XTAP_355 VGND VPWR sky130_fd_sc_hd__tapvpwrvgnd_1
XTAP_344 VGND VPWR sky130_fd_sc_hd__tapvpwrvgnd_1
XTAP_333 VGND VPWR sky130_fd_sc_hd__tapvpwrvgnd_1
XTAP_322 VGND VPWR sky130_fd_sc_hd__tapvpwrvgnd_1
XTAP_311 VGND VPWR sky130_fd_sc_hd__tapvpwrvgnd_1
XTAP_300 VGND VPWR sky130_fd_sc_hd__tapvpwrvgnd_1
XPHY_17 VGND VGND VPWR VPWR sky130_fd_sc_hd__decap_3
XPHY_28 VGND VGND VPWR VPWR sky130_fd_sc_hd__decap_3
X_1008_ _0313_ _0413_ VGND VGND VPWR VPWR _0414_ sky130_fd_sc_hd__nor2_1
XFILLER_0_16_91 VGND VGND VPWR VPWR sky130_fd_sc_hd__fill_1
XPHY_39 VGND VGND VPWR VPWR sky130_fd_sc_hd__decap_3
XFILLER_0_29_293 VPWR VGND VPWR VGND sky130_ef_sc_hd__decap_12
XFILLER_0_50_233 VPWR VGND VPWR VGND sky130_ef_sc_hd__decap_12
XFILLER_0_12_27 VGND VGND VPWR VPWR sky130_fd_sc_hd__fill_1
XFILLER_0_50_277 VPWR VGND VPWR VGND sky130_ef_sc_hd__decap_12
Xoutput3 net3 VGND VGND VPWR VPWR done sky130_fd_sc_hd__clkbuf_4
X_1290_ clknet_4_9_0_clk _0124_ VGND VGND VPWR VPWR u_sram.mem\[8\]\[0\] sky130_fd_sc_hd__dfxtp_1
XTAP_141 VGND VPWR sky130_fd_sc_hd__tapvpwrvgnd_1
XTAP_130 VGND VPWR sky130_fd_sc_hd__tapvpwrvgnd_1
XTAP_152 VGND VPWR sky130_fd_sc_hd__tapvpwrvgnd_1
XTAP_163 VGND VPWR sky130_fd_sc_hd__tapvpwrvgnd_1
XTAP_174 VGND VPWR sky130_fd_sc_hd__tapvpwrvgnd_1
XTAP_185 VGND VPWR sky130_fd_sc_hd__tapvpwrvgnd_1
XTAP_196 VGND VPWR sky130_fd_sc_hd__tapvpwrvgnd_1
XFILLER_0_32_288 VPWR VGND VPWR VGND sky130_ef_sc_hd__decap_12
XFILLER_0_23_15 VGND VGND VPWR VPWR sky130_fd_sc_hd__decap_4
X_0790_ u_sram.mem\[46\]\[1\] _0169_ _0203_ _0238_ VGND VGND VPWR VPWR _0239_ sky130_fd_sc_hd__a31o_1
X_1273_ clknet_4_14_0_clk _0107_ VGND VGND VPWR VPWR u_sram.mem\[16\]\[1\] sky130_fd_sc_hd__dfxtp_1
XFILLER_0_3_69 VPWR VGND VPWR VGND sky130_ef_sc_hd__decap_12
X_0988_ _0317_ _0399_ VGND VGND VPWR VPWR _0400_ sky130_fd_sc_hd__or2_1
XFILLER_0_1_193 VGND VGND VPWR VPWR sky130_fd_sc_hd__decap_6
XFILLER_0_49_152 VPWR VGND VPWR VGND sky130_ef_sc_hd__decap_12
XFILLER_0_18_15 VPWR VGND VPWR VGND sky130_ef_sc_hd__decap_12
XFILLER_0_20_225 VGND VGND VPWR VPWR sky130_fd_sc_hd__fill_2
X_0911_ _0344_ _0346_ VGND VGND VPWR VPWR _0347_ sky130_fd_sc_hd__or2_1
X_0842_ u_sram.mem\[14\]\[0\] _0203_ _0288_ _0289_ VGND VGND VPWR VPWR _0290_ sky130_fd_sc_hd__a211o_1
X_0773_ _0219_ _0220_ _0221_ VGND VGND VPWR VPWR _0222_ sky130_fd_sc_hd__or3_1
XFILLER_0_11_258 VPWR VGND VPWR VGND sky130_ef_sc_hd__decap_12
X_1325_ clknet_4_11_0_clk u_fsm.next_state\[1\] net12 VGND VGND VPWR VPWR u_fsm.state\[1\]
+ sky130_fd_sc_hd__dfrtp_1
X_1256_ clknet_4_6_0_clk _0090_ VGND VGND VPWR VPWR u_sram.mem\[25\]\[0\] sky130_fd_sc_hd__dfxtp_1
X_1187_ clknet_4_8_0_clk _0021_ VGND VGND VPWR VPWR u_sram.mem\[59\]\[1\] sky130_fd_sc_hd__dfxtp_1
XFILLER_0_19_303 VGND VGND VPWR VPWR sky130_fd_sc_hd__decap_3
XFILLER_0_37_166 VGND VGND VPWR VPWR sky130_fd_sc_hd__fill_2
XFILLER_0_20_27 VGND VGND VPWR VPWR sky130_fd_sc_hd__fill_1
XFILLER_0_20_38 VGND VGND VPWR VPWR sky130_fd_sc_hd__fill_2
X_1110_ _0357_ _0466_ VGND VGND VPWR VPWR _0478_ sky130_fd_sc_hd__or2_1
Xmax_cap2 _0178_ VGND VGND VPWR VPWR net163 sky130_fd_sc_hd__buf_1
X_1041_ _0372_ _0411_ VGND VGND VPWR VPWR _0435_ sky130_fd_sc_hd__nor2_1
XFILLER_0_43_169 VGND VGND VPWR VPWR sky130_fd_sc_hd__decap_4
XFILLER_0_43_136 VGND VGND VPWR VPWR sky130_fd_sc_hd__decap_8
XFILLER_0_9_46 VGND VGND VPWR VPWR sky130_fd_sc_hd__decap_4
X_0825_ u_sram.mem\[46\]\[0\] _0169_ _0203_ _0242_ VGND VGND VPWR VPWR _0273_ sky130_fd_sc_hd__a31o_1
XFILLER_0_28_155 VGND VGND VPWR VPWR sky130_fd_sc_hd__fill_1
XFILLER_0_28_166 VGND VGND VPWR VPWR sky130_fd_sc_hd__fill_1
X_0687_ _0576_ _0307_ _0577_ VGND VGND VPWR VPWR _0578_ sky130_fd_sc_hd__o21ai_1
X_0756_ u_sram.mem\[2\]\[1\] net6 _0204_ u_sram.mem\[9\]\[1\] VGND VGND VPWR VPWR
+ _0205_ sky130_fd_sc_hd__a22o_1
X_1239_ clknet_4_7_0_clk _0073_ VGND VGND VPWR VPWR u_sram.mem\[33\]\[1\] sky130_fd_sc_hd__dfxtp_1
X_1308_ clknet_4_13_0_clk net19 net15 VGND VGND VPWR VPWR u_sram.addr_r\[0\] sky130_fd_sc_hd__dfrtp_4
XFILLER_0_36_3 VPWR VGND VPWR VGND sky130_ef_sc_hd__decap_12
XFILLER_0_19_144 VGND VGND VPWR VPWR sky130_fd_sc_hd__fill_1
XFILLER_0_42_191 VGND VGND VPWR VPWR sky130_fd_sc_hd__decap_4
XFILLER_0_31_15 VGND VGND VPWR VPWR sky130_fd_sc_hd__fill_1
XFILLER_0_25_147 VPWR VGND VPWR VGND sky130_ef_sc_hd__decap_12
XFILLER_0_40_128 VGND VGND VPWR VPWR sky130_fd_sc_hd__decap_3
XFILLER_0_0_225 VPWR VGND VPWR VGND sky130_ef_sc_hd__decap_12
XFILLER_0_0_258 VPWR VGND VPWR VGND sky130_ef_sc_hd__decap_12
X_0610_ _0492_ net99 _0530_ VGND VGND VPWR VPWR _0532_ sky130_fd_sc_hd__mux2_1
X_1024_ _0342_ VGND VGND VPWR VPWR _0424_ sky130_fd_sc_hd__buf_2
XFILLER_0_48_217 VPWR VGND VPWR VGND sky130_ef_sc_hd__decap_12
XFILLER_0_8_303 VGND VGND VPWR VPWR sky130_fd_sc_hd__decap_3
X_0808_ u_sram.mem\[20\]\[0\] net8 _0184_ VGND VGND VPWR VPWR _0256_ sky130_fd_sc_hd__and3_1
XFILLER_0_21_81 VPWR VGND VPWR VGND sky130_ef_sc_hd__decap_12
X_0739_ u_sram.mem\[22\]\[1\] _0175_ _0185_ _0187_ VGND VGND VPWR VPWR _0188_ sky130_fd_sc_hd__a31o_1
XFILLER_0_47_261 VPWR VGND VPWR VGND sky130_ef_sc_hd__decap_12
XFILLER_0_30_150 VPWR VGND VPWR VGND sky130_ef_sc_hd__decap_12
Xhold71 u_sram.mem\[31\]\[0\] VGND VGND VPWR VPWR net87 sky130_fd_sc_hd__dlygate4sd3_1
Xhold82 u_sram.mem\[44\]\[0\] VGND VGND VPWR VPWR net98 sky130_fd_sc_hd__dlygate4sd3_1
Xhold60 u_sram.mem\[17\]\[1\] VGND VGND VPWR VPWR net76 sky130_fd_sc_hd__dlygate4sd3_1
Xhold93 u_sram.mem\[4\]\[0\] VGND VGND VPWR VPWR net109 sky130_fd_sc_hd__dlygate4sd3_1
XFILLER_0_26_15 VPWR VGND VPWR VGND sky130_ef_sc_hd__decap_12
Xclkbuf_4_14_0_clk clknet_0_clk VGND VGND VPWR VPWR clknet_4_14_0_clk sky130_fd_sc_hd__clkbuf_8
XTAP_367 VGND VPWR sky130_fd_sc_hd__tapvpwrvgnd_1
XTAP_356 VGND VPWR sky130_fd_sc_hd__tapvpwrvgnd_1
XTAP_345 VGND VPWR sky130_fd_sc_hd__tapvpwrvgnd_1
XTAP_334 VGND VPWR sky130_fd_sc_hd__tapvpwrvgnd_1
XTAP_323 VGND VPWR sky130_fd_sc_hd__tapvpwrvgnd_1
XTAP_312 VGND VPWR sky130_fd_sc_hd__tapvpwrvgnd_1
XTAP_301 VGND VPWR sky130_fd_sc_hd__tapvpwrvgnd_1
X_1007_ _0412_ VGND VGND VPWR VPWR _0413_ sky130_fd_sc_hd__buf_2
XPHY_18 VGND VGND VPWR VPWR sky130_fd_sc_hd__decap_3
XPHY_29 VGND VGND VPWR VPWR sky130_fd_sc_hd__decap_3
XFILLER_0_44_253 VPWR VGND VPWR VGND sky130_ef_sc_hd__decap_12
XFILLER_0_50_245 VGND VGND VPWR VPWR sky130_fd_sc_hd__decap_6
XFILLER_0_50_289 VPWR VGND VPWR VGND sky130_ef_sc_hd__decap_12
Xoutput4 net4 VGND VGND VPWR VPWR pass_fail sky130_fd_sc_hd__buf_2
XFILLER_0_37_69 VGND VGND VPWR VPWR sky130_fd_sc_hd__decap_4
XFILLER_0_26_253 VGND VGND VPWR VPWR sky130_fd_sc_hd__decap_6
XFILLER_0_26_286 VGND VGND VPWR VPWR sky130_fd_sc_hd__decap_8
XTAP_142 VGND VPWR sky130_fd_sc_hd__tapvpwrvgnd_1
XTAP_131 VGND VPWR sky130_fd_sc_hd__tapvpwrvgnd_1
XTAP_120 VGND VPWR sky130_fd_sc_hd__tapvpwrvgnd_1
XTAP_153 VGND VPWR sky130_fd_sc_hd__tapvpwrvgnd_1
XTAP_164 VGND VPWR sky130_fd_sc_hd__tapvpwrvgnd_1
XTAP_175 VGND VPWR sky130_fd_sc_hd__tapvpwrvgnd_1
XTAP_186 VGND VPWR sky130_fd_sc_hd__tapvpwrvgnd_1
XTAP_197 VGND VPWR sky130_fd_sc_hd__tapvpwrvgnd_1
XFILLER_0_23_201 VGND VGND VPWR VPWR sky130_fd_sc_hd__fill_1
XFILLER_0_3_15 VPWR VGND VPWR VGND sky130_ef_sc_hd__decap_12
X_1272_ clknet_4_12_0_clk _0106_ VGND VGND VPWR VPWR u_sram.mem\[17\]\[0\] sky130_fd_sc_hd__dfxtp_1
X_0987_ _0309_ _0332_ _0344_ VGND VGND VPWR VPWR _0399_ sky130_fd_sc_hd__or3_4
XFILLER_0_49_164 VGND VGND VPWR VPWR sky130_fd_sc_hd__fill_1
XFILLER_0_18_27 VGND VGND VPWR VPWR sky130_fd_sc_hd__fill_1
XFILLER_0_18_49 VGND VGND VPWR VPWR sky130_fd_sc_hd__decap_4
XFILLER_0_34_15 VPWR VGND VPWR VGND sky130_ef_sc_hd__decap_12
X_0910_ _0315_ _0345_ VGND VGND VPWR VPWR _0346_ sky130_fd_sc_hd__or2_1
X_0772_ u_sram.mem\[49\]\[1\] net11 _0179_ u_sram.mem\[51\]\[1\] VGND VGND VPWR VPWR
+ _0221_ sky130_fd_sc_hd__a22o_1
X_0841_ u_sram.mem\[13\]\[0\] _0207_ _0189_ u_sram.mem\[15\]\[0\] VGND VGND VPWR VPWR
+ _0289_ sky130_fd_sc_hd__a22o_1
XFILLER_0_11_204 VPWR VGND VPWR VGND sky130_ef_sc_hd__decap_12
X_1186_ clknet_4_2_0_clk _0020_ VGND VGND VPWR VPWR u_sram.mem\[60\]\[0\] sky130_fd_sc_hd__dfxtp_1
X_1324_ clknet_4_11_0_clk u_fsm.next_state\[0\] net13 VGND VGND VPWR VPWR u_fsm.state\[0\]
+ sky130_fd_sc_hd__dfrtp_2
X_1255_ clknet_4_3_0_clk _0089_ VGND VGND VPWR VPWR u_sram.mem\[25\]\[1\] sky130_fd_sc_hd__dfxtp_1
XFILLER_0_6_253 VPWR VGND VPWR VGND sky130_ef_sc_hd__decap_12
XFILLER_0_10_292 VGND VGND VPWR VPWR sky130_fd_sc_hd__decap_6
XFILLER_0_29_15 VGND VGND VPWR VPWR sky130_fd_sc_hd__decap_4
XFILLER_0_45_47 VGND VGND VPWR VPWR sky130_fd_sc_hd__decap_3
X_1040_ _0342_ VGND VGND VPWR VPWR _0434_ sky130_fd_sc_hd__clkbuf_4
XFILLER_0_0_27 VGND VGND VPWR VPWR sky130_fd_sc_hd__fill_1
XFILLER_0_51_181 VGND VGND VPWR VPWR sky130_fd_sc_hd__decap_4
X_0755_ u_sram.addr_r\[1\] u_sram.addr_r\[2\] u_sram.addr_r\[3\] u_sram.addr_r\[0\]
+ VGND VGND VPWR VPWR _0204_ sky130_fd_sc_hd__and4bb_4
X_0824_ u_sram.mem\[19\]\[0\] _0179_ _0185_ VGND VGND VPWR VPWR _0272_ sky130_fd_sc_hd__and3_1
XFILLER_0_28_178 VGND VGND VPWR VPWR sky130_fd_sc_hd__fill_1
XFILLER_0_10_83 VGND VGND VPWR VPWR sky130_fd_sc_hd__fill_1
X_0686_ u_pattern_gen.state_r\[0\] u_comparator.read_data\[0\] VGND VGND VPWR VPWR
+ _0577_ sky130_fd_sc_hd__xnor2_1
XFILLER_0_19_81 VPWR VGND VPWR VGND sky130_ef_sc_hd__decap_12
X_1238_ clknet_4_13_0_clk _0072_ VGND VGND VPWR VPWR u_sram.mem\[34\]\[0\] sky130_fd_sc_hd__dfxtp_1
X_1169_ clknet_4_2_0_clk _0006_ VGND VGND VPWR VPWR u_sram.mem\[63\]\[1\] sky130_fd_sc_hd__dfxtp_1
X_1307_ clknet_4_10_0_clk _0141_ net12 VGND VGND VPWR VPWR u_fsm.protocol_error sky130_fd_sc_hd__dfrtp_1
XFILLER_0_29_3 VPWR VGND VPWR VGND sky130_ef_sc_hd__decap_12
XFILLER_0_34_137 VGND VGND VPWR VPWR sky130_fd_sc_hd__decap_3
XFILLER_0_25_159 VGND VGND VPWR VPWR sky130_fd_sc_hd__decap_8
XFILLER_0_33_192 VGND VGND VPWR VPWR sky130_fd_sc_hd__fill_1
XFILLER_0_0_237 VPWR VGND VPWR VGND sky130_ef_sc_hd__decap_12
X_1023_ _0423_ VGND VGND VPWR VPWR _0050_ sky130_fd_sc_hd__clkbuf_1
XFILLER_0_48_229 VPWR VGND VPWR VGND sky130_ef_sc_hd__decap_12
X_0807_ u_sram.mem\[24\]\[0\] _0185_ _0186_ _0254_ VGND VGND VPWR VPWR _0255_ sky130_fd_sc_hd__a31o_1
XFILLER_0_16_159 VGND VGND VPWR VPWR sky130_fd_sc_hd__fill_1
XFILLER_0_21_93 VPWR VGND VPWR VGND sky130_ef_sc_hd__decap_12
X_0738_ u_sram.mem\[24\]\[1\] _0184_ _0186_ VGND VGND VPWR VPWR _0187_ sky130_fd_sc_hd__and3_1
X_0669_ _0567_ VGND VGND VPWR VPWR _0139_ sky130_fd_sc_hd__clkbuf_1
XFILLER_0_1_81 VPWR VGND VPWR VGND sky130_ef_sc_hd__decap_12
XFILLER_0_47_273 VGND VGND VPWR VPWR sky130_fd_sc_hd__decap_6
XFILLER_0_30_162 VGND VGND VPWR VPWR sky130_fd_sc_hd__decap_4
Xhold61 u_sram.mem\[31\]\[1\] VGND VGND VPWR VPWR net77 sky130_fd_sc_hd__dlygate4sd3_1
Xhold72 u_sram.mem\[59\]\[0\] VGND VGND VPWR VPWR net88 sky130_fd_sc_hd__dlygate4sd3_1
Xhold83 u_sram.mem\[12\]\[0\] VGND VGND VPWR VPWR net99 sky130_fd_sc_hd__dlygate4sd3_1
Xhold94 u_sram.mem\[2\]\[1\] VGND VGND VPWR VPWR net110 sky130_fd_sc_hd__dlygate4sd3_1
Xhold50 u_sram.mem\[43\]\[1\] VGND VGND VPWR VPWR net66 sky130_fd_sc_hd__dlygate4sd3_1
XFILLER_0_26_27 VGND VGND VPWR VPWR sky130_fd_sc_hd__fill_1
XFILLER_0_42_15 VPWR VGND VPWR VGND sky130_ef_sc_hd__decap_12
XFILLER_0_38_251 VGND VGND VPWR VPWR sky130_fd_sc_hd__fill_1
XFILLER_0_6_15 VPWR VGND VPWR VGND sky130_ef_sc_hd__decap_12
XTAP_368 VGND VPWR sky130_fd_sc_hd__tapvpwrvgnd_1
XTAP_357 VGND VPWR sky130_fd_sc_hd__tapvpwrvgnd_1
XTAP_346 VGND VPWR sky130_fd_sc_hd__tapvpwrvgnd_1
XTAP_335 VGND VPWR sky130_fd_sc_hd__tapvpwrvgnd_1
XTAP_324 VGND VPWR sky130_fd_sc_hd__tapvpwrvgnd_1
XTAP_313 VGND VPWR sky130_fd_sc_hd__tapvpwrvgnd_1
XTAP_302 VGND VPWR sky130_fd_sc_hd__tapvpwrvgnd_1
X_1006_ _0362_ _0411_ VGND VGND VPWR VPWR _0412_ sky130_fd_sc_hd__or2_1
XPHY_19 VGND VGND VPWR VPWR sky130_fd_sc_hd__decap_3
XFILLER_0_44_265 VPWR VGND VPWR VGND sky130_ef_sc_hd__decap_12
XFILLER_0_44_221 VPWR VGND VPWR VGND sky130_ef_sc_hd__decap_12
XFILLER_0_8_145 VGND VGND VPWR VPWR sky130_fd_sc_hd__decap_8
XFILLER_0_12_195 VGND VGND VPWR VPWR sky130_fd_sc_hd__fill_1
XFILLER_0_12_29 VPWR VGND VPWR VGND sky130_ef_sc_hd__decap_12
XFILLER_0_37_15 VGND VGND VPWR VPWR sky130_fd_sc_hd__decap_8
XFILLER_0_5_148 VGND VGND VPWR VPWR sky130_fd_sc_hd__fill_2
XFILLER_0_26_232 VPWR VGND VPWR VGND sky130_ef_sc_hd__decap_12
XTAP_132 VGND VPWR sky130_fd_sc_hd__tapvpwrvgnd_1
XTAP_121 VGND VPWR sky130_fd_sc_hd__tapvpwrvgnd_1
XTAP_110 VGND VPWR sky130_fd_sc_hd__tapvpwrvgnd_1
XTAP_143 VGND VPWR sky130_fd_sc_hd__tapvpwrvgnd_1
XTAP_154 VGND VPWR sky130_fd_sc_hd__tapvpwrvgnd_1
XTAP_165 VGND VPWR sky130_fd_sc_hd__tapvpwrvgnd_1
XTAP_176 VGND VPWR sky130_fd_sc_hd__tapvpwrvgnd_1
XTAP_187 VGND VPWR sky130_fd_sc_hd__tapvpwrvgnd_1
XTAP_198 VGND VPWR sky130_fd_sc_hd__tapvpwrvgnd_1
XFILLER_0_27_92 VGND VGND VPWR VPWR sky130_fd_sc_hd__fill_2
XFILLER_0_11_3 VPWR VGND VPWR VGND sky130_ef_sc_hd__decap_12
XFILLER_0_17_221 VGND VGND VPWR VPWR sky130_fd_sc_hd__decap_3
XFILLER_0_17_276 VGND VGND VPWR VPWR sky130_fd_sc_hd__fill_1
Xclkbuf_4_13_0_clk clknet_0_clk VGND VGND VPWR VPWR clknet_4_13_0_clk sky130_fd_sc_hd__clkbuf_8
X_1271_ clknet_4_12_0_clk _0105_ VGND VGND VPWR VPWR u_sram.mem\[17\]\[1\] sky130_fd_sc_hd__dfxtp_1
XFILLER_0_3_27 VPWR VGND VPWR VGND sky130_ef_sc_hd__decap_12
XFILLER_0_46_305 VGND VGND VPWR VPWR sky130_fd_sc_hd__fill_1
X_0986_ _0398_ VGND VGND VPWR VPWR _0038_ sky130_fd_sc_hd__clkbuf_1
XFILLER_0_14_246 VGND VGND VPWR VPWR sky130_fd_sc_hd__decap_6
XFILLER_0_37_305 VGND VGND VPWR VPWR sky130_fd_sc_hd__fill_1
XFILLER_0_50_15 VPWR VGND VPWR VGND sky130_ef_sc_hd__decap_12
XFILLER_0_34_27 VGND VGND VPWR VPWR sky130_fd_sc_hd__fill_1
X_0771_ u_sram.mem\[52\]\[1\] net9 _0200_ u_sram.mem\[60\]\[1\] VGND VGND VPWR VPWR
+ _0220_ sky130_fd_sc_hd__a22o_1
X_0840_ u_sram.mem\[10\]\[0\] _0199_ _0179_ u_sram.mem\[3\]\[0\] VGND VGND VPWR VPWR
+ _0288_ sky130_fd_sc_hd__a22o_1
XFILLER_0_11_216 VGND VGND VPWR VPWR sky130_fd_sc_hd__decap_8
X_1323_ clknet_4_11_0_clk _0146_ net13 VGND VGND VPWR VPWR net4 sky130_fd_sc_hd__dfrtp_1
X_1254_ clknet_4_5_0_clk _0088_ VGND VGND VPWR VPWR u_sram.mem\[26\]\[0\] sky130_fd_sc_hd__dfxtp_1
X_1185_ clknet_4_8_0_clk _0019_ VGND VGND VPWR VPWR u_sram.mem\[60\]\[1\] sky130_fd_sc_hd__dfxtp_1
X_0969_ _0328_ _0309_ _0332_ VGND VGND VPWR VPWR _0387_ sky130_fd_sc_hd__or3b_2
XFILLER_0_6_265 VPWR VGND VPWR VGND sky130_ef_sc_hd__decap_12
XFILLER_0_37_179 VGND VGND VPWR VPWR sky130_fd_sc_hd__decap_4
XFILLER_0_45_15 VPWR VGND VPWR VGND sky130_ef_sc_hd__decap_12
XFILLER_0_9_15 VPWR VGND VPWR VGND sky130_ef_sc_hd__decap_12
XFILLER_0_28_102 VGND VGND VPWR VPWR sky130_fd_sc_hd__fill_1
X_0754_ u_sram.addr_r\[0\] u_sram.addr_r\[1\] u_sram.addr_r\[3\] u_sram.addr_r\[2\]
+ VGND VGND VPWR VPWR _0203_ sky130_fd_sc_hd__and4b_4
XFILLER_0_3_279 VGND VGND VPWR VPWR sky130_fd_sc_hd__fill_1
X_0685_ u_comparator.read_data\[1\] VGND VGND VPWR VPWR _0576_ sky130_fd_sc_hd__inv_2
X_0823_ _0267_ _0268_ _0269_ _0270_ VGND VGND VPWR VPWR _0271_ sky130_fd_sc_hd__or4_1
X_1306_ clknet_4_10_0_clk _0140_ VGND VGND VPWR VPWR u_sram.mem\[0\]\[0\] sky130_fd_sc_hd__dfxtp_1
XFILLER_0_19_93 VGND VGND VPWR VPWR sky130_fd_sc_hd__decap_8
X_1237_ clknet_4_13_0_clk _0071_ VGND VGND VPWR VPWR u_sram.mem\[34\]\[1\] sky130_fd_sc_hd__dfxtp_1
X_1099_ _0471_ VGND VGND VPWR VPWR _0078_ sky130_fd_sc_hd__clkbuf_1
X_1168_ _0503_ net76 _0513_ VGND VGND VPWR VPWR _0514_ sky130_fd_sc_hd__mux2_1
XFILLER_0_34_105 VPWR VGND VPWR VGND sky130_ef_sc_hd__decap_12
XFILLER_0_42_160 VGND VGND VPWR VPWR sky130_fd_sc_hd__fill_2
XFILLER_0_21_300 VGND VGND VPWR VPWR sky130_fd_sc_hd__decap_6
XFILLER_0_25_127 VGND VGND VPWR VPWR sky130_fd_sc_hd__decap_4
XFILLER_0_0_249 VGND VGND VPWR VPWR sky130_fd_sc_hd__decap_3
X_1022_ _0422_ net41 _0420_ VGND VGND VPWR VPWR _0423_ sky130_fd_sc_hd__mux2_1
X_0737_ u_sram.addr_r\[0\] _0170_ _0163_ u_sram.addr_r\[3\] VGND VGND VPWR VPWR _0186_
+ sky130_fd_sc_hd__nor4b_2
X_0806_ u_sram.mem\[40\]\[0\] _0168_ _0186_ VGND VGND VPWR VPWR _0254_ sky130_fd_sc_hd__and3_1
X_0668_ _0308_ net29 _0566_ VGND VGND VPWR VPWR _0567_ sky130_fd_sc_hd__mux2_1
XFILLER_0_41_3 VPWR VGND VPWR VGND sky130_ef_sc_hd__decap_12
X_0599_ _0525_ VGND VGND VPWR VPWR _0111_ sky130_fd_sc_hd__clkbuf_1
XFILLER_0_1_93 VPWR VGND VPWR VGND sky130_ef_sc_hd__decap_12
XFILLER_0_15_160 VGND VGND VPWR VPWR sky130_fd_sc_hd__decap_8
XFILLER_0_15_193 VGND VGND VPWR VPWR sky130_fd_sc_hd__fill_1
XFILLER_0_30_130 VGND VGND VPWR VPWR sky130_fd_sc_hd__fill_1
Xhold40 u_sram.mem\[58\]\[0\] VGND VGND VPWR VPWR net56 sky130_fd_sc_hd__dlygate4sd3_1
Xhold73 u_sram.mem\[32\]\[0\] VGND VGND VPWR VPWR net89 sky130_fd_sc_hd__dlygate4sd3_1
Xhold95 u_sram.mem\[24\]\[0\] VGND VGND VPWR VPWR net111 sky130_fd_sc_hd__dlygate4sd3_1
Xhold62 u_sram.mem\[30\]\[1\] VGND VGND VPWR VPWR net78 sky130_fd_sc_hd__dlygate4sd3_1
Xhold84 u_sram.mem\[49\]\[1\] VGND VGND VPWR VPWR net100 sky130_fd_sc_hd__dlygate4sd3_1
Xhold51 u_sram.mem\[23\]\[1\] VGND VGND VPWR VPWR net67 sky130_fd_sc_hd__dlygate4sd3_1
XFILLER_0_42_27 VGND VGND VPWR VPWR sky130_fd_sc_hd__fill_1
XTAP_314 VGND VPWR sky130_fd_sc_hd__tapvpwrvgnd_1
XTAP_303 VGND VPWR sky130_fd_sc_hd__tapvpwrvgnd_1
XFILLER_0_6_49 VGND VGND VPWR VPWR sky130_fd_sc_hd__decap_3
XFILLER_0_6_27 VGND VGND VPWR VPWR sky130_fd_sc_hd__fill_1
XFILLER_0_21_185 VPWR VGND VPWR VGND sky130_ef_sc_hd__decap_12
XTAP_369 VGND VPWR sky130_fd_sc_hd__tapvpwrvgnd_1
XTAP_358 VGND VPWR sky130_fd_sc_hd__tapvpwrvgnd_1
XTAP_347 VGND VPWR sky130_fd_sc_hd__tapvpwrvgnd_1
XTAP_336 VGND VPWR sky130_fd_sc_hd__tapvpwrvgnd_1
XTAP_325 VGND VPWR sky130_fd_sc_hd__tapvpwrvgnd_1
X_1005_ u_addr_gen.addr\[4\] u_addr_gen.addr\[5\] net15 VGND VGND VPWR VPWR _0411_
+ sky130_fd_sc_hd__nand3b_4
XFILLER_0_8_102 VGND VGND VPWR VPWR sky130_fd_sc_hd__decap_8
XFILLER_0_16_61 VGND VGND VPWR VPWR sky130_fd_sc_hd__fill_1
XFILLER_0_16_83 VGND VGND VPWR VPWR sky130_fd_sc_hd__fill_1
XFILLER_0_29_241 VGND VGND VPWR VPWR sky130_fd_sc_hd__decap_8
XFILLER_0_44_277 VPWR VGND VPWR VGND sky130_ef_sc_hd__decap_12
XFILLER_0_44_233 VPWR VGND VPWR VGND sky130_ef_sc_hd__decap_12
XFILLER_0_5_105 VGND VGND VPWR VPWR sky130_fd_sc_hd__decap_6
XFILLER_0_26_211 VGND VGND VPWR VPWR sky130_fd_sc_hd__fill_1
XFILLER_0_26_244 VGND VGND VPWR VPWR sky130_fd_sc_hd__decap_8
XTAP_144 VGND VPWR sky130_fd_sc_hd__tapvpwrvgnd_1
XTAP_133 VGND VPWR sky130_fd_sc_hd__tapvpwrvgnd_1
XTAP_122 VGND VPWR sky130_fd_sc_hd__tapvpwrvgnd_1
XTAP_111 VGND VPWR sky130_fd_sc_hd__tapvpwrvgnd_1
XTAP_155 VGND VPWR sky130_fd_sc_hd__tapvpwrvgnd_1
XTAP_166 VGND VPWR sky130_fd_sc_hd__tapvpwrvgnd_1
.ends
